|   stm32f405_415_407_417_wlcsp90 IBIS Model
[IBIS ver]   4.2
[File name]  stm32f405_415_407_417_wlcsp90.ibs
[File Rev]   1.3
[Date]   05-30-2014
[Source] Data Created at STMicroelectronics
[Notes]   File originated from ELDO simulations.
[Disclaimer]  This information is for modeling purpose only and is
   not guaranted. The information is subject to change without
   notice.
[Copyright] Copyright 2014 STMicroelectronics Inc.
[Component] stm32f405_415_407_417_wlcsp90
[Manufacturer] STMicroelectronics
[Package]
| variable   typ   min   max
R_pkg   0.0   NA   NA
L_pkg   0.0H   NA   NA
C_pkg   0.0F   NA   NA
[Pin]   signal_name   model_name   R_pin   L_pin   C_pin
A10 VBAT POWER
A9 PC13-ANTI_TAMP io8p_arwsudq_ft_v33
B10 PC14-OSC32_IN io8p_arsudq_ft
B9 PC15-OSC32_OUT io8p_arwsudq_ft
C9 VSS GND
B8 VDD POWER
F10 PH0 io8p_arwsudq_ft
F9 PH1 io8p_arwsudq_ft
G10 NRST ioreset_ft_v33
E10 PC0 io8p_ar3wsudq_ft
D10 PC2 io8p_ar3wsudq_ft
E9 PC3 io8p_ar3wsudq_ft
H10 VSSA GND
G9 VREF+ POWER
C10 PA0 io8p_ar3wsudq_ft_v33
F8 PA1 io8p_ar3wsudq_ft
J10 PA2 io8p_ar3wsudq_ft
H9 PA3 io8p_ar3wsudq_ft
E5 VSS GND
D9 BYPASS_REG io8p_arwsudq_ft_v33
E4 VDD POWER
J9 PA4 io8p_ar3wsudq_ft
G8 PA5 io8p_ar3wsudq_ft
H8 PA6 io8p_ar3wsudq_ft
J8 PA7 io8p_ar3wsudq_ft
G7 PB0 io8p_ar3wsudq_ft
H7 PB1 io8p_ar3wsudq_ft
J7 PB2 io8p_ar3wsudq_ft
G6 PE7 io8p_arwsudq_ft
H6 PE8 io8p_arwsudq_ft
J6 PE9 io8p_arwsudq_ft
E6 VDD POWER
F6 PE10 io8p_arwsudq_ft
J5 PE11 io8p_arwsudq_ft
H5 PE12 io8p_arwsudq_ft
G5 PE13 io8p_arwsudq_ft
F5 PE14 io8p_arwsudq_ft
G4 PE15 io8p_arwsudq_ft
H4 PB10 io8p_arsudq_i2cin_ft
J4 PB11 io8p_arsudq_i2cin_ft
J3 PB12 io8usb_id_otg_ft
J1 PB13 io8usb_vbus_otg_ft
J2 PB14 io8usb_lsfs_otg_ft
H1 PB15 io8usb_lsfs_otg_ft
H2 PD8 io8p_arwsudq_ft
H3 PD9 io8p_arwsudq_ft
G3 PD10 io8p_arwsudq_ft
G1 PD11 io8p_arwsudq_ft
G2 PD12 io8p_arwsudq_ft
F2 PD14 io8p_arwsudq_ft
F1 PD15 io8p_arwsudq_ft
F3 PC6 io8p_arwsudq_ft
E1 PC7 io8p_arwsudq_ft
E2 PC8 io8p_arwsudq_ft
E3 PC9 io8p_arsudq_i2cin_ft
D1 PA8 io8p_arsudq_i2cin_ft
D2 PA9 io8usb_vbus_otg_ft
D3 PA10 io8usb_id_otg_ft
C1 PA11 io8usb_lsfs_otg_ft
C2 PA12 io8usb_lsfs_otg_ft
D4 PA13 io8p_arwsudq_ft
B1 VCAP2 POWER
E7 VSS GND
C3 PI0 io8p_arwsudq_ft
B2 PI1 io8p_arwsudq_ft
A2 PA14 io8p_arwsudq_ft
B3 PA15 io8p_ar3wsudq_ft
D5 PC10 io8p_arwsudq_ft
C4 PC11 io8p_arwsudq_ft
A3 PC12 io8p_arwsudq_ft
D6 PD0 io8p_arwsudq_ft
C5 PD1 io8p_arwsudq_ft
B4 PD2 io8p_arwsudq_ft
A4 PD4 io8p_arwsudq_ft
C6 PD5 io8p_arwsudq_ft
B5 PD6 io8p_arwsudq_ft
A5 PD7 io8p_arwsudq_ft
E8 VSS GND
F7 VDD POWER
B6 PB3 io8p_arwsudq_ft
A6 PB4 io8p_arwsudq_ft
D7 PB5 io8p_ar3wsudq_ft
C7 PB6 io8p_arsudq_i2cin_ft
B7 PB7 io8p_arsudq_i2cin_ft
A7 BOOT0 vpp_test_hv
D8 PB8 io8p_arsudq_i2cin_ft
C8 PB9 io8p_arsudq_i2cin_ft
A8 PDR_ON io8p_arsudq_ft_v33
A1 VDD POWER
[Diff Pin]   inv_pin   vdiff   tdelay_typ  tdelay_min  tdelay_max
J2   H1   200mV   NA   NA   NA
C1   C2   200mV   NA   NA   NA
[Model Selector] io8p_ar3wsudq_ft
io8p00_ar3wsudq_ft_pd_lv  "SPEED00 1P8V, PD=40kOhm"
io8p00_ar3wsudq_ft_pu_lv  "SPEED00 1P8V, PU=40kOhm"
io8p00_ar3wsudq_ft_lv  "SPEED00 1P8V"
io8p01_ar3wsudq_ft_pd_lv  "SPEED01 1P8V, PD=40kOhm"
io8p01_ar3wsudq_ft_pu_lv  "SPEED01 1P8V, PU=40kOhm"
io8p01_ar3wsudq_ft_lv  "SPEED01 1P8V"
io8p10_ar3wsudq_ft_pd_lv  "SPEED10 1P8V, PD=40kOhm"
io8p10_ar3wsudq_ft_pu_lv  "SPEED10 1P8V, PU=40kOhm"
io8p10_ar3wsudq_ft_lv  "SPEED10 1P8V"
io8p11_ar3wsudq_ft_pd_lv  "SPEED11 1P8V, PD=40kOhm"
io8p11_ar3wsudq_ft_pu_lv  "SPEED11 1P8V, PU=40kOhm"
io8p11_ar3wsudq_ft_lv  "SPEED11 1P8V"
io8p00_ar3wsudq_ft_pd  "SPEED00, PD=40kOhm"
io8p00_ar3wsudq_ft_pu  "SPEED00, PU=40kOhm"
io8p00_ar3wsudq_ft  "SPEED00"
io8p01_ar3wsudq_ft_pd  "SPEED01, PD=40kOhm"
io8p01_ar3wsudq_ft_pu  "SPEED01, PU=40kOhm"
io8p01_ar3wsudq_ft  "SPEED01"
io8p10_ar3wsudq_ft_pd  "SPEED10, PD=40kOhm"
io8p10_ar3wsudq_ft_pu  "SPEED10, PU=40kOhm"
io8p10_ar3wsudq_ft  "SPEED10"
io8p11_ar3wsudq_ft_pd  "SPEED11, PD=40kOhm"
io8p11_ar3wsudq_ft_pu  "SPEED11, PU=40kOhm"
io8p11_ar3wsudq_ft  "SPEED11"
[Model Selector] io8p_ar3wsudq_ft_v33
io8p00_ar3wsudq_ft_v33_pd_lv  "SPEED00 1P8V, PD=40kOhm"
io8p00_ar3wsudq_ft_v33_pu_lv  "SPEED00 1P8V, PU=40kOhm"
io8p00_ar3wsudq_ft_v33_lv  "SPEED00 1P8V"
io8p01_ar3wsudq_ft_v33_pd_lv  "SPEED01 1P8V, PD=40kOhm"
io8p01_ar3wsudq_ft_v33_pu_lv  "SPEED01 1P8V, PU=40kOhm"
io8p01_ar3wsudq_ft_v33_lv  "SPEED01 1P8V"
io8p10_ar3wsudq_ft_v33_pd_lv  "SPEED10 1P8V, PD=40kOhm"
io8p10_ar3wsudq_ft_v33_pu_lv  "SPEED10 1P8V, PU=40kOhm"
io8p10_ar3wsudq_ft_v33_lv  "SPEED10 1P8V"
io8p11_ar3wsudq_ft_v33_pd_lv  "SPEED11 1P8V, PD=40kOhm"
io8p11_ar3wsudq_ft_v33_pu_lv  "SPEED11 1P8V, PU=40kOhm"
io8p11_ar3wsudq_ft_v33_lv  "SPEED11 1P8V"
io8p00_ar3wsudq_ft_v33_pd  "SPEED00, PD=40kOhm"
io8p00_ar3wsudq_ft_v33_pu  "SPEED00, PU=40kOhm"
io8p00_ar3wsudq_ft_v33  "SPEED00"
io8p01_ar3wsudq_ft_v33_pd  "SPEED01, PD=40kOhm"
io8p01_ar3wsudq_ft_v33_pu  "SPEED01, PU=40kOhm"
io8p01_ar3wsudq_ft_v33  "SPEED01"
io8p10_ar3wsudq_ft_v33_pd  "SPEED10, PD=40kOhm"
io8p10_ar3wsudq_ft_v33_pu  "SPEED10, PU=40kOhm"
io8p10_ar3wsudq_ft_v33  "SPEED10"
io8p11_ar3wsudq_ft_v33_pd  "SPEED11, PD=40kOhm"
io8p11_ar3wsudq_ft_v33_pu  "SPEED11, PU=40kOhm"
io8p11_ar3wsudq_ft_v33  "SPEED11"
[Model Selector] io8p_arsudq_ft
io8p00_arsudq_ft_pd_lv  "SPEED00 1P8V, PD=40kOhm"
io8p00_arsudq_ft_pu_lv  "SPEED00 1P8V, PU=40kOhm"
io8p00_arsudq_ft_lv  "SPEED00 1P8V"
io8p01_arsudq_ft_pd_lv  "SPEED01 1P8V, PD=40kOhm"
io8p01_arsudq_ft_pu_lv  "SPEED01 1P8V, PU=40kOhm"
io8p01_arsudq_ft_lv  "SPEED01 1P8V"
io8p10_arsudq_ft_pd_lv  "SPEED10 1P8V, PD=40kOhm"
io8p10_arsudq_ft_pu_lv  "SPEED10 1P8V, PU=40kOhm"
io8p10_arsudq_ft_lv  "SPEED10 1P8V"
io8p11_arsudq_ft_pd_lv  "SPEED11 1P8V, PD=40kOhm"
io8p11_arsudq_ft_pu_lv  "SPEED11 1P8V, PU=40kOhm"
io8p11_arsudq_ft_lv  "SPEED11 1P8V"
io8p00_arsudq_ft_pd  "SPEED00, PD=40kOhm"
io8p00_arsudq_ft_pu  "SPEED00, PU=40kOhm"
io8p00_arsudq_ft  "SPEED00"
io8p01_arsudq_ft_pd  "SPEED01, PD=40kOhm"
io8p01_arsudq_ft_pu  "SPEED01, PU=40kOhm"
io8p01_arsudq_ft  "SPEED01"
io8p10_arsudq_ft_pd  "SPEED10, PD=40kOhm"
io8p10_arsudq_ft_pu  "SPEED10, PU=40kOhm"
io8p10_arsudq_ft  "SPEED10"
io8p11_arsudq_ft_pd  "SPEED11, PD=40kOhm"
io8p11_arsudq_ft_pu  "SPEED11, PU=40kOhm"
io8p11_arsudq_ft  "SPEED11"
[Model Selector] io8p_arsudq_ft_v33
io8p00_arsudq_ft_v33_pd_lv  "SPEED00 1P8V, PD=40kOhm"
io8p00_arsudq_ft_v33_pu_lv  "SPEED00 1P8V, PU=40kOhm"
io8p00_arsudq_ft_v33_lv  "SPEED00 1P8V"
io8p01_arsudq_ft_v33_pd_lv  "SPEED01 1P8V, PD=40kOhm"
io8p01_arsudq_ft_v33_pu_lv  "SPEED01 1P8V, PU=40kOhm"
io8p01_arsudq_ft_v33_lv  "SPEED01 1P8V"
io8p10_arsudq_ft_v33_pd_lv  "SPEED10 1P8V, PD=40kOhm"
io8p10_arsudq_ft_v33_pu_lv  "SPEED10 1P8V, PU=40kOhm"
io8p10_arsudq_ft_v33_lv  "SPEED10 1P8V"
io8p11_arsudq_ft_v33_pd_lv  "SPEED11 1P8V, PD=40kOhm"
io8p11_arsudq_ft_v33_pu_lv  "SPEED11 1P8V, PU=40kOhm"
io8p11_arsudq_ft_v33_lv  "SPEED11 1P8V"
io8p00_arsudq_ft_v33_pd  "SPEED00, PD=40kOhm"
io8p00_arsudq_ft_v33_pu  "SPEED00, PU=40kOhm"
io8p00_arsudq_ft_v33  "SPEED00"
io8p01_arsudq_ft_v33_pd  "SPEED01, PD=40kOhm"
io8p01_arsudq_ft_v33_pu  "SPEED01, PU=40kOhm"
io8p01_arsudq_ft_v33  "SPEED01"
io8p10_arsudq_ft_v33_pd  "SPEED10, PD=40kOhm"
io8p10_arsudq_ft_v33_pu  "SPEED10, PU=40kOhm"
io8p10_arsudq_ft_v33  "SPEED10"
io8p11_arsudq_ft_v33_pd  "SPEED11, PD=40kOhm"
io8p11_arsudq_ft_v33_pu  "SPEED11, PU=40kOhm"
io8p11_arsudq_ft_v33  "SPEED11"
[Model Selector] io8p_arsudq_i2cin_ft
io8p00_arsudq_i2cin_ft_pd_lv  "SPEED00 1P8V, PD=40kOhm"
io8p00_arsudq_i2cin_ft_pu_lv  "SPEED00 1P8V, PU=40kOhm"
io8p00_arsudq_i2cin_ft_lv  "SPEED00 1P8V"
io8p01_arsudq_i2cin_ft_pd_lv  "SPEED01 1P8V, PD=40kOhm"
io8p01_arsudq_i2cin_ft_pu_lv  "SPEED01 1P8V, PU=40kOhm"
io8p01_arsudq_i2cin_ft_lv  "SPEED01 1P8V"
io8p10_arsudq_i2cin_ft_pd_lv  "SPEED10 1P8V, PD=40kOhm"
io8p10_arsudq_i2cin_ft_pu_lv  "SPEED10 1P8V, PU=40kOhm"
io8p10_arsudq_i2cin_ft_lv  "SPEED10 1P8V"
io8p11_arsudq_i2cin_ft_pd_lv  "SPEED11 1P8V, PD=40kOhm"
io8p11_arsudq_i2cin_ft_pu_lv  "SPEED11 1P8V, PU=40kOhm"
io8p11_arsudq_i2cin_ft_lv  "SPEED11 1P8V"
io8p00_arsudq_i2cin_ft_pd  "SPEED00, PD=40kOhm"
io8p00_arsudq_i2cin_ft_pu  "SPEED00, PU=40kOhm"
io8p00_arsudq_i2cin_ft  "SPEED00"
io8p01_arsudq_i2cin_ft_pd  "SPEED01, PD=40kOhm"
io8p01_arsudq_i2cin_ft_pu  "SPEED01, PU=40kOhm"
io8p01_arsudq_i2cin_ft  "SPEED01"
io8p10_arsudq_i2cin_ft_pd  "SPEED10, PD=40kOhm"
io8p10_arsudq_i2cin_ft_pu  "SPEED10, PU=40kOhm"
io8p10_arsudq_i2cin_ft  "SPEED10"
io8p11_arsudq_i2cin_ft_pd  "SPEED11, PD=40kOhm"
io8p11_arsudq_i2cin_ft_pu  "SPEED11, PU=40kOhm"
io8p11_arsudq_i2cin_ft  "SPEED11"
[Model Selector] io8p_arwsudq_ft
io8p00_arwsudq_ft_pd_lv  "SPEED00 1P8V, PD=40kOhm"
io8p00_arwsudq_ft_pu_lv  "SPEED00 1P8V, PU=40kOhm"
io8p00_arwsudq_ft_lv  "SPEED00 1P8V"
io8p01_arwsudq_ft_pd_lv  "SPEED01 1P8V, PD=40kOhm"
io8p01_arwsudq_ft_pu_lv  "SPEED01 1P8V, PU=40kOhm"
io8p01_arwsudq_ft_lv  "SPEED01 1P8V"
io8p10_arwsudq_ft_pd_lv  "SPEED10 1P8V, PD=40kOhm"
io8p10_arwsudq_ft_pu_lv  "SPEED10 1P8V, PU=40kOhm"
io8p10_arwsudq_ft_lv  "SPEED10 1P8V"
io8p11_arwsudq_ft_pd_lv  "SPEED11 1P8V, PD=40kOhm"
io8p11_arwsudq_ft_pu_lv  "SPEED11 1P8V, PU=40kOhm"
io8p11_arwsudq_ft_lv  "SPEED11 1P8V"
io8p00_arwsudq_ft_pd  "SPEED00, PD=40kOhm"
io8p00_arwsudq_ft_pu  "SPEED00, PU=40kOhm"
io8p00_arwsudq_ft  "SPEED00"
io8p01_arwsudq_ft_pd  "SPEED01, PD=40kOhm"
io8p01_arwsudq_ft_pu  "SPEED01, PU=40kOhm"
io8p01_arwsudq_ft  "SPEED01"
io8p10_arwsudq_ft_pd  "SPEED10, PD=40kOhm"
io8p10_arwsudq_ft_pu  "SPEED10, PU=40kOhm"
io8p10_arwsudq_ft  "SPEED10"
io8p11_arwsudq_ft_pd  "SPEED11, PD=40kOhm"
io8p11_arwsudq_ft_pu  "SPEED11, PU=40kOhm"
io8p11_arwsudq_ft  "SPEED11"
[Model Selector] io8p_arwsudq_ft_v33
io8p00_arwsudq_ft_v33_pd_lv  "SPEED00 1P8V, PD=40kOhm"
io8p00_arwsudq_ft_v33_pu_lv  "SPEED00 1P8V, PU=40kOhm"
io8p00_arwsudq_ft_v33_lv  "SPEED00 1P8V"
io8p01_arwsudq_ft_v33_pd_lv  "SPEED01 1P8V, PD=40kOhm"
io8p01_arwsudq_ft_v33_pu_lv  "SPEED01 1P8V, PU=40kOhm"
io8p01_arwsudq_ft_v33_lv  "SPEED01 1P8V"
io8p10_arwsudq_ft_v33_pd_lv  "SPEED10 1P8V, PD=40kOhm"
io8p10_arwsudq_ft_v33_pu_lv  "SPEED10 1P8V, PU=40kOhm"
io8p10_arwsudq_ft_v33_lv  "SPEED10 1P8V"
io8p11_arwsudq_ft_v33_pd_lv  "SPEED11 1P8V, PD=40kOhm"
io8p11_arwsudq_ft_v33_pu_lv  "SPEED11 1P8V, PU=40kOhm"
io8p11_arwsudq_ft_v33_lv  "SPEED11 1P8V"
io8p00_arwsudq_ft_v33_pd  "SPEED00, PD=40kOhm"
io8p00_arwsudq_ft_v33_pu  "SPEED00, PU=40kOhm"
io8p00_arwsudq_ft_v33  "SPEED00"
io8p01_arwsudq_ft_v33_pd  "SPEED01, PD=40kOhm"
io8p01_arwsudq_ft_v33_pu  "SPEED01, PU=40kOhm"
io8p01_arwsudq_ft_v33  "SPEED01"
io8p10_arwsudq_ft_v33_pd  "SPEED10, PD=40kOhm"
io8p10_arwsudq_ft_v33_pu  "SPEED10, PU=40kOhm"
io8p10_arwsudq_ft_v33  "SPEED10"
io8p11_arwsudq_ft_v33_pd  "SPEED11, PD=40kOhm"
io8p11_arwsudq_ft_v33_pu  "SPEED11, PU=40kOhm"
io8p11_arwsudq_ft_v33  "SPEED11"
[Model Selector] io8usb_id_otg_ft
io8p00_id_otg_ft_pd_lv  "SPEED00 1P8V, PD=14kOhm"
io8p00_id_otg_ft_pu_lv  "SPEED00 1P8V, PU=14kOhm"
io8p00_id_otg_ft_lv  "SPEED00 1P8V"
io8p01_id_otg_ft_pd_lv  "SPEED01 1P8V, PD=14kOhm"
io8p01_id_otg_ft_pu_lv  "SPEED01 1P8V, PU=14kOhm"
io8p01_id_otg_ft_lv  "SPEED01 1P8V"
io8p10_id_otg_ft_pd_lv  "SPEED10 1P8V, PD=14kOhm"
io8p10_id_otg_ft_pu_lv  "SPEED10 1P8V, PU=14kOhm"
io8p10_id_otg_ft_lv  "SPEED10 1P8V"
io8p11_id_otg_ft_pd_lv  "SPEED11 1P8V, PD=14kOhm"
io8p11_id_otg_ft_pu_lv  "SPEED11 1P8V, PU=14kOhm"
io8p11_id_otg_ft_lv  "SPEED11 1P8V"
io8p00_id_otg_ft_pd  "SPEED00, PD=14kOhm"
io8p00_id_otg_ft_pu  "SPEED00, PU=14kOhm"
io8p00_id_otg_ft  "SPEED00"
io8p01_id_otg_ft_pd  "SPEED01, PD=14kOhm"
io8p01_id_otg_ft_pu  "SPEED01, PU=14kOhm"
io8p01_id_otg_ft  "SPEED01"
io8p10_id_otg_ft_pd  "SPEED10, PD=14kOhm"
io8p10_id_otg_ft_pu  "SPEED10, PU=14kOhm"
io8p10_id_otg_ft  "SPEED10"
io8p11_id_otg_ft_pd  "SPEED11, PD=14kOhm"
io8p11_id_otg_ft_pu  "SPEED11, PU=14kOhm"
io8p11_id_otg_ft  "SPEED11"
[Model Selector] io8usb_lsfs_otg_ft
io8usb_ls_otg_ft_dpdn_pd  "LS USB DP/DN IO + PD=20kOhm"
io8usb_ls_otg_ft_dpdn_pupu2  "LS USB DP/DN IO + PU/PU2=2.2kOhm"
io8usb_ls_otg_ft_dpdn_pu2  "LS USB DP/DN IO + PU2=1.2kOhm"
io8usb_ls_otg_ft_dpdn_pu  "LS USB DP/DN IO + PU=1.2kOhm"
io8usb_ls_otg_ft_dpdn  "LS USB DP/DN IO"
io8usb_fs_otg_ft_dpdn_pd  "HS USB DP/DN IO + PD=20kOhm"
io8usb_fs_otg_ft_dpdn_pupu2  "HS USB DP/DN IO + PU/PU2=2.2kOhm"
io8usb_fs_otg_ft_dpdn_pu2  "HS USB DP/DN IO + PU2=1.2kOhm"
io8usb_fs_otg_ft_dpdn_pu  "HS USB DP/DN IO + PU=1.2kOhm"
io8usb_fs_otg_ft_dpdn  "HS USB DP/DN IO"
io8p00_lsfs_otg_ft_pd_lv  "SPEED00 1P8V, PD=40kOhm"
io8p00_lsfs_otg_ft_pu_lv  "SPEED00 1P8V, PU=40kOhm"
io8p00_lsfs_otg_ft_lv  "SPEED00 1P8V"
io8p01_lsfs_otg_ft_pd_lv  "SPEED01 1P8V, PD=40kOhm"
io8p01_lsfs_otg_ft_pu_lv  "SPEED01 1P8V, PU=40kOhm"
io8p01_lsfs_otg_ft_lv  "SPEED01 1P8V"
io8p10_lsfs_otg_ft_pd_lv  "SPEED10 1P8V, PD=40kOhm"
io8p10_lsfs_otg_ft_pu_lv  "SPEED10 1P8V, PU=40kOhm"
io8p10_lsfs_otg_ft_lv  "SPEED10 1P8V"
io8p11_lsfs_otg_ft_pd_lv  "SPEED11 1P8V, PD=40kOhm"
io8p11_lsfs_otg_ft_pu_lv  "SPEED11 1P8V, PU=40kOhm"
io8p11_lsfs_otg_ft_lv  "SPEED11 1P8V"
io8p00_lsfs_otg_ft_pd  "SPEED00, PD=40kOhm"
io8p00_lsfs_otg_ft_pu  "SPEED00, PU=40kOhm"
io8p00_lsfs_otg_ft  "SPEED00"
io8p01_lsfs_otg_ft_pd  "SPEED01, PD=40kOhm"
io8p01_lsfs_otg_ft_pu  "SPEED01, PU=40kOhm"
io8p01_lsfs_otg_ft  "SPEED01"
io8p10_lsfs_otg_ft_pd  "SPEED10, PD=40kOhm"
io8p10_lsfs_otg_ft_pu  "SPEED10, PU=40kOhm"
io8p10_lsfs_otg_ft  "SPEED10"
io8p11_lsfs_otg_ft_pd  "SPEED11, PD=40kOhm"
io8p11_lsfs_otg_ft_pu  "SPEED11, PU=40kOhm"
io8p11_lsfs_otg_ft  "SPEED11"
[Model Selector] io8usb_vbus_otg_ft
io8psenb_vbus_otg_ft  "VBUS PULSE, SENSE VB"
io8psenab_vbus_otg_ft  "VBUS PULSE, SENSE VA and VB"
io8psena_vbus_otg_ft  "VBUS PULSE, SENSE VA"
io8psen_vbus_otg_ft  "VBUS PULSE"
io8p00_vbus_otg_ft_pd_lv  "SPEED00 1P8V, PD=40kOhm"
io8p00_vbus_otg_ft_pu_lv  "SPEED00 1P8V, PU=40kOhm"
io8p00_vbus_otg_ft_lv  "SPEED00 1P8V"
io8p01_vbus_otg_ft_pd_lv  "SPEED01 1P8V, PD=40kOhm"
io8p01_vbus_otg_ft_pu_lv  "SPEED01 1P8V, PU=40kOhm"
io8p01_vbus_otg_ft_lv  "SPEED01 1P8V"
io8p10_vbus_otg_ft_pd_lv  "SPEED10 1P8V, PD=40kOhm"
io8p10_vbus_otg_ft_pu_lv  "SPEED10 1P8V, PU=40kOhm"
io8p10_vbus_otg_ft_lv  "SPEED10 1P8V"
io8p11_vbus_otg_ft_pd_lv  "SPEED11 1P8V, PD=40kOhm"
io8p11_vbus_otg_ft_pu_lv  "SPEED11 1P8V, PU=40kOhm"
io8p11_vbus_otg_ft_lv  "SPEED11 1P8V"
io8p00_vbus_otg_ft_pd  "SPEED00, PD=40kOhm"
io8p00_vbus_otg_ft_pu  "SPEED00, PU=40kOhm"
io8p00_vbus_otg_ft  "SPEED00"
io8p01_vbus_otg_ft_pd  "SPEED01, PD=40kOhm"
io8p01_vbus_otg_ft_pu  "SPEED01, PU=40kOhm"
io8p01_vbus_otg_ft  "SPEED01"
io8p10_vbus_otg_ft_pd  "SPEED10, PD=40kOhm"
io8p10_vbus_otg_ft_pu  "SPEED10, PU=40kOhm"
io8p10_vbus_otg_ft  "SPEED10"
io8p11_vbus_otg_ft_pd  "SPEED11, PD=40kOhm"
io8p11_vbus_otg_ft_pu  "SPEED11, PU=40kOhm"
io8p11_vbus_otg_ft  "SPEED11"
[Model Selector] ioreset_ft_v33
ioreset_ft_v33_pu_lv  "ioreset 1P8V + PU=40kOhm"
ioreset_ft_v33_nopu_lv  "ioreset 1P8V"
ioreset_ft_v33_pu  "ioreset + PU=40kOhm"
ioreset_ft_v33_nopu  "ioreset"
[Model Selector] vpp_test_hv
vpp_test_hv_2p4  "Input Buffer 1P8V"
vpp_test_hv_3p3  "Input Buffer"
| Models and submodels in the file (260): io8p00_ar3wsudq_ft_pd_lv (I/O), io8p00_ar3wsudq_ft_pu_lv (I/O), io8p00_ar3wsudq_ft_lv (I/O), io8p01_ar3wsudq_ft_pd_lv (I/O), io8p01_ar3wsudq_ft_pu_lv (I/O), io8p01_ar3wsudq_ft_lv (I/O), io8p10_ar3wsudq_ft_pd_lv (I/O), io8p10_ar3wsudq_ft_pu_lv (I/O), io8p10_ar3wsudq_ft_lv (I/O), io8p11_ar3wsudq_ft_pd_lv (I/O), io8p11_ar3wsudq_ft_pu_lv (I/O), io8p11_ar3wsudq_ft_lv (I/O), io8p00_ar3wsudq_ft_pd (I/O), io8p00_ar3wsudq_ft_pu (I/O), io8p00_ar3wsudq_ft (I/O), io8p01_ar3wsudq_ft_pd (I/O), io8p01_ar3wsudq_ft_pu (I/O), io8p01_ar3wsudq_ft (I/O), io8p10_ar3wsudq_ft_pd (I/O), io8p10_ar3wsudq_ft_pu (I/O), io8p10_ar3wsudq_ft (I/O), io8p11_ar3wsudq_ft_pd (I/O), io8p11_ar3wsudq_ft_pu (I/O), io8p11_ar3wsudq_ft (I/O), io8p00_ar3wsudq_ft_v33_pd_lv (I/O), io8p00_ar3wsudq_ft_v33_pu_lv (I/O), io8p00_ar3wsudq_ft_v33_lv (I/O), io8p01_ar3wsudq_ft_v33_pd_lv (I/O), io8p01_ar3wsudq_ft_v33_pu_lv (I/O), io8p01_ar3wsudq_ft_v33_lv (I/O), io8p10_ar3wsudq_ft_v33_pd_lv (I/O), io8p10_ar3wsudq_ft_v33_pu_lv (I/O), io8p10_ar3wsudq_ft_v33_lv (I/O), io8p11_ar3wsudq_ft_v33_pd_lv (I/O), io8p11_ar3wsudq_ft_v33_pu_lv (I/O), io8p11_ar3wsudq_ft_v33_lv (I/O), io8p00_ar3wsudq_ft_v33_pd (I/O), io8p00_ar3wsudq_ft_v33_pu (I/O), io8p00_ar3wsudq_ft_v33 (I/O), io8p01_ar3wsudq_ft_v33_pd (I/O), io8p01_ar3wsudq_ft_v33_pu (I/O), io8p01_ar3wsudq_ft_v33 (I/O), io8p10_ar3wsudq_ft_v33_pd (I/O), io8p10_ar3wsudq_ft_v33_pu (I/O), io8p10_ar3wsudq_ft_v33 (I/O), io8p11_ar3wsudq_ft_v33_pd (I/O), io8p11_ar3wsudq_ft_v33_pu (I/O), io8p11_ar3wsudq_ft_v33 (I/O), io8p00_arsudq_ft_pd_lv (I/O), io8p00_arsudq_ft_pu_lv (I/O), io8p00_arsudq_ft_lv (I/O), io8p01_arsudq_ft_pd_lv (I/O), io8p01_arsudq_ft_pu_lv (I/O), io8p01_arsudq_ft_lv (I/O), io8p10_arsudq_ft_pd_lv (I/O), io8p10_arsudq_ft_pu_lv (I/O), io8p10_arsudq_ft_lv (I/O), io8p11_arsudq_ft_pd_lv (I/O), io8p11_arsudq_ft_pu_lv (I/O), io8p11_arsudq_ft_lv (I/O), io8p00_arsudq_ft_pd (I/O), io8p00_arsudq_ft_pu (I/O), io8p00_arsudq_ft (I/O), io8p01_arsudq_ft_pd (I/O), io8p01_arsudq_ft_pu (I/O), io8p01_arsudq_ft (I/O), io8p10_arsudq_ft_pd (I/O), io8p10_arsudq_ft_pu (I/O), io8p10_arsudq_ft (I/O), io8p11_arsudq_ft_pd (I/O), io8p11_arsudq_ft_pu (I/O), io8p11_arsudq_ft (I/O), io8p00_arsudq_ft_v33_pd_lv (I/O), io8p00_arsudq_ft_v33_pu_lv (I/O), io8p00_arsudq_ft_v33_lv (I/O), io8p01_arsudq_ft_v33_pd_lv (I/O), io8p01_arsudq_ft_v33_pu_lv (I/O), io8p01_arsudq_ft_v33_lv (I/O), io8p10_arsudq_ft_v33_pd_lv (I/O), io8p10_arsudq_ft_v33_pu_lv (I/O)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
