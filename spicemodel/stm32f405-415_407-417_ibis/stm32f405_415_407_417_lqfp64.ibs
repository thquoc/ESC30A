|   stm32f405_415_407_417_lqfp64 IBIS Model
[IBIS ver]   4.2
[File name]  stm32f405_415_407_417_lqfp64.ibs
[File Rev]   1.3
[Date]   05-30-2014
[Source] Data Created at STMicroelectronics
[Notes]   File originated from ELDO simulations.
[Disclaimer]  This information is for modeling purpose only and is
   not guaranted. The information is subject to change without
   notice.
[Copyright] Copyright 2014 STMicroelectronics Inc.
[Component] stm32f405_415_407_417_lqfp64
[Manufacturer] STMicroelectronics
[Package]
| variable   typ   min   max
R_pkg   0.0   NA   NA
L_pkg   0.0H   NA   NA
C_pkg   0.0F   NA   NA
[Pin]   signal_name   model_name   R_pin   L_pin   C_pin
1   VBAT   POWER   69.0E-3   4.2E-9   120.0E-15
2   PC13   io8p_arwsudq_ft_v33   63.8E-3   3.7E-9   93.5E-15
3   PC14   io8p_arwsudq_ft   59.3E-3   3.2E-9   71.0E-15
4   PC15   io8p_arsudq_ft   55.7E-3   2.8E-9   52.7E-15
5   PH0   io8p_arsudq_ft   52.9E-3   2.6E-9   38.4E-15
6   PH1   io8p_arsudq_ft   50.9E-3   2.3E-9   28.2E-15
7   NRST   ioreset_ft_v33   49.7E-3   2.2E-9   22.0E-15
8   PC0   io8p_ar3wsudq_ft   49.3E-3   2.2E-9   20.0E-15
9   PC1   io8p_ar3wsudq_ft   49.3E-3   2.2E-9   20.0E-15
10   PC2   io8p_ar3wsudq_ft   49.7E-3   2.2E-9   22.0E-15
11   PC3   io8p_ar3wsudq_ft   50.9E-3   2.3E-9   28.2E-15
12   VREFP   GND   52.9E-3   2.6E-9   38.4E-15
13   VREFM   POWER   55.7E-3   2.8E-9   52.7E-15
14   PA0   io8p_ar3wsudq_ft_v33   59.3E-3   3.2E-9   71.0E-15
15   PA1   io8p_ar3wsudq_ft   63.8E-3   3.7E-9   93.5E-15
16   PA2   io8p_ar3wsudq_ft   69.0E-3   4.2E-9   120.0E-15
17   PA3   io8p_ar3wsudq_ft   69.0E-3   4.2E-9   120.0E-15
18   VSS   GND   63.8E-3   3.7E-9   93.5E-15
19   VDD   POWER   59.3E-3   3.2E-9   71.0E-15
20   PA4   io8p_ar3wsudq_ft   55.7E-3   2.8E-9   52.7E-15
21   PA5   io8p_ar3wsudq_ft   52.9E-3   2.6E-9   38.4E-15
22   PA6   io8p_ar3wsudq_ft   50.9E-3   2.3E-9   28.2E-15
23   PA7   io8p_ar3wsudq_ft   49.7E-3   2.2E-9   22.0E-15
24   PC4   io8p_ar3wsudq_ft   49.3E-3   2.2E-9   20.0E-15
25   PC5   io8p_ar3wsudq_ft   49.3E-3   2.2E-9   20.0E-15
26   PB0   io8p_ar3wsudq_ft   49.7E-3   2.2E-9   22.0E-15
27   PB1   io8p_ar3wsudq_ft   50.9E-3   2.3E-9   28.2E-15
28   PB2   io8p_ar3wsudq_ft   52.9E-3   2.6E-9   38.4E-15
29   PB10   io8p_arsudq_i2cin_ft   55.7E-3   2.8E-9   52.7E-15
30   PB11   io8p_arsudq_i2cin_ft   59.3E-3   3.2E-9   71.0E-15
31   VCAP1   POWER   63.8E-3   3.7E-9   93.5E-15
32   VDD   POWER   69.0E-3   4.2E-9   120.0E-15
33   PB12   io8usb_id_otg_ft   69.0E-3   4.2E-9   120.0E-15
34   PB13   io8usb_vbus_otg_ft   63.8E-3   3.7E-9   93.5E-15
35   PB14   io8usb_lsfs_otg_ft   59.3E-3   3.2E-9   71.0E-15
36   PB15   io8usb_lsfs_otg_ft   55.7E-3   2.8E-9   52.7E-15
37   PC6   io8p_arsudq_ft   52.9E-3   2.6E-9   38.4E-15
38   PC7   io8p_arsudq_ft   50.9E-3   2.3E-9   28.2E-15
39   PC8   io8p_arsudq_ft   49.7E-3   2.2E-9   22.0E-15
40   PC9   io8p_arsudq_i2cin_ft   49.3E-3   2.2E-9   20.0E-15
41   PA8   io8p_arsudq_i2cin_ft   49.3E-3   2.2E-9   20.0E-15
42   PA9   io8usb_vbus_otg_ft   49.7E-3   2.2E-9   22.0E-15
43   PA10   io8usb_id_otg_ft   50.9E-3   2.3E-9   28.2E-15
44   PA11   io8usb_lsfs_otg_ft   52.9E-3   2.6E-9   38.4E-15
45   PA12   io8usb_lsfs_otg_ft   55.7E-3   2.8E-9   52.7E-15
46   PA13   io8p_arsudq_ft   59.3E-3   3.2E-9   71.0E-15
47   VCAP2   POWER   63.8E-3   3.7E-9   93.5E-15
48   VDD   POWER   69.0E-3   4.2E-9   120.0E-15
49   PA14   io8p_arsudq_ft   69.0E-3   4.2E-9   120.0E-15
50   PA15   io8p_arsudq_ft   63.8E-3   3.7E-9   93.5E-15
51   PC10   io8p_arsudq_ft   59.3E-3   3.2E-9   71.0E-15
52   PC11   io8p_arsudq_ft   55.7E-3   2.8E-9   52.7E-15
53   PC12   io8p_arsudq_ft   52.9E-3   2.6E-9   38.4E-15
54   PD2   io8p_arsudq_ft   50.9E-3   2.3E-9   28.2E-15
55   PB3   io8p_arsudq_ft   49.7E-3   2.2E-9   22.0E-15
56   PB4   io8p_arsudq_ft   49.3E-3   2.2E-9   20.0E-15
57   PB5   io8p_ar3wsudq_ft   49.3E-3   2.2E-9   20.0E-15
58   PB6   io8p_arsudq_i2cin_ft   49.7E-3   2.2E-9   22.0E-15
59   PB7   io8p_arsudq_i2cin_ft   50.9E-3   2.3E-9   28.2E-15
60   BOOT0   vpp_test_hv   52.9E-3   2.6E-9   38.4E-15
61   PB8   io8p_arsudq_i2cin_ft   55.7E-3   2.8E-9   52.7E-15
62   PB9   io8p_arsudq_i2cin_ft   59.3E-3   3.2E-9   71.0E-15
63   VSS   GND   63.8E-3   3.7E-9   93.5E-15
64   VDD   POWER   69.0E-3   4.2E-9   120.0E-15
[Diff Pin]   inv_pin   vdiff   tdelay_typ  tdelay_min  tdelay_max
36   35   200mV   NA   NA   NA
45   44   200mV   NA   NA   NA
[Model Selector] io8p_ar3wsudq_ft
io8p00_ar3wsudq_ft_pd_lv  "SPEED00 1P8V, PD=40kOhm"
io8p00_ar3wsudq_ft_pu_lv  "SPEED00 1P8V, PU=40kOhm"
io8p00_ar3wsudq_ft_lv  "SPEED00 1P8V"
io8p01_ar3wsudq_ft_pd_lv  "SPEED01 1P8V, PD=40kOhm"
io8p01_ar3wsudq_ft_pu_lv  "SPEED01 1P8V, PU=40kOhm"
io8p01_ar3wsudq_ft_lv  "SPEED01 1P8V"
io8p10_ar3wsudq_ft_pd_lv  "SPEED10 1P8V, PD=40kOhm"
io8p10_ar3wsudq_ft_pu_lv  "SPEED10 1P8V, PU=40kOhm"
io8p10_ar3wsudq_ft_lv  "SPEED10 1P8V"
io8p11_ar3wsudq_ft_pd_lv  "SPEED11 1P8V, PD=40kOhm"
io8p11_ar3wsudq_ft_pu_lv  "SPEED11 1P8V, PU=40kOhm"
io8p11_ar3wsudq_ft_lv  "SPEED11 1P8V"
io8p00_ar3wsudq_ft_pd  "SPEED00, PD=40kOhm"
io8p00_ar3wsudq_ft_pu  "SPEED00, PU=40kOhm"
io8p00_ar3wsudq_ft  "SPEED00"
io8p01_ar3wsudq_ft_pd  "SPEED01, PD=40kOhm"
io8p01_ar3wsudq_ft_pu  "SPEED01, PU=40kOhm"
io8p01_ar3wsudq_ft  "SPEED01"
io8p10_ar3wsudq_ft_pd  "SPEED10, PD=40kOhm"
io8p10_ar3wsudq_ft_pu  "SPEED10, PU=40kOhm"
io8p10_ar3wsudq_ft  "SPEED10"
io8p11_ar3wsudq_ft_pd  "SPEED11, PD=40kOhm"
io8p11_ar3wsudq_ft_pu  "SPEED11, PU=40kOhm"
io8p11_ar3wsudq_ft  "SPEED11"
[Model Selector] io8p_ar3wsudq_ft_v33
io8p00_ar3wsudq_ft_v33_pd_lv  "SPEED00 1P8V, PD=40kOhm"
io8p00_ar3wsudq_ft_v33_pu_lv  "SPEED00 1P8V, PU=40kOhm"
io8p00_ar3wsudq_ft_v33_lv  "SPEED00 1P8V"
io8p01_ar3wsudq_ft_v33_pd_lv  "SPEED01 1P8V, PD=40kOhm"
io8p01_ar3wsudq_ft_v33_pu_lv  "SPEED01 1P8V, PU=40kOhm"
io8p01_ar3wsudq_ft_v33_lv  "SPEED01 1P8V"
io8p10_ar3wsudq_ft_v33_pd_lv  "SPEED10 1P8V, PD=40kOhm"
io8p10_ar3wsudq_ft_v33_pu_lv  "SPEED10 1P8V, PU=40kOhm"
io8p10_ar3wsudq_ft_v33_lv  "SPEED10 1P8V"
io8p11_ar3wsudq_ft_v33_pd_lv  "SPEED11 1P8V, PD=40kOhm"
io8p11_ar3wsudq_ft_v33_pu_lv  "SPEED11 1P8V, PU=40kOhm"
io8p11_ar3wsudq_ft_v33_lv  "SPEED11 1P8V"
io8p00_ar3wsudq_ft_v33_pd  "SPEED00, PD=40kOhm"
io8p00_ar3wsudq_ft_v33_pu  "SPEED00, PU=40kOhm"
io8p00_ar3wsudq_ft_v33  "SPEED00"
io8p01_ar3wsudq_ft_v33_pd  "SPEED01, PD=40kOhm"
io8p01_ar3wsudq_ft_v33_pu  "SPEED01, PU=40kOhm"
io8p01_ar3wsudq_ft_v33  "SPEED01"
io8p10_ar3wsudq_ft_v33_pd  "SPEED10, PD=40kOhm"
io8p10_ar3wsudq_ft_v33_pu  "SPEED10, PU=40kOhm"
io8p10_ar3wsudq_ft_v33  "SPEED10"
io8p11_ar3wsudq_ft_v33_pd  "SPEED11, PD=40kOhm"
io8p11_ar3wsudq_ft_v33_pu  "SPEED11, PU=40kOhm"
io8p11_ar3wsudq_ft_v33  "SPEED11"
[Model Selector] io8p_arsudq_ft
io8p00_arsudq_ft_pd_lv  "SPEED00 1P8V, PD=40kOhm"
io8p00_arsudq_ft_pu_lv  "SPEED00 1P8V, PU=40kOhm"
io8p00_arsudq_ft_lv  "SPEED00 1P8V"
io8p01_arsudq_ft_pd_lv  "SPEED01 1P8V, PD=40kOhm"
io8p01_arsudq_ft_pu_lv  "SPEED01 1P8V, PU=40kOhm"
io8p01_arsudq_ft_lv  "SPEED01 1P8V"
io8p10_arsudq_ft_pd_lv  "SPEED10 1P8V, PD=40kOhm"
io8p10_arsudq_ft_pu_lv  "SPEED10 1P8V, PU=40kOhm"
io8p10_arsudq_ft_lv  "SPEED10 1P8V"
io8p11_arsudq_ft_pd_lv  "SPEED11 1P8V, PD=40kOhm"
io8p11_arsudq_ft_pu_lv  "SPEED11 1P8V, PU=40kOhm"
io8p11_arsudq_ft_lv  "SPEED11 1P8V"
io8p00_arsudq_ft_pd  "SPEED00, PD=40kOhm"
io8p00_arsudq_ft_pu  "SPEED00, PU=40kOhm"
io8p00_arsudq_ft  "SPEED00"
io8p01_arsudq_ft_pd  "SPEED01, PD=40kOhm"
io8p01_arsudq_ft_pu  "SPEED01, PU=40kOhm"
io8p01_arsudq_ft  "SPEED01"
io8p10_arsudq_ft_pd  "SPEED10, PD=40kOhm"
io8p10_arsudq_ft_pu  "SPEED10, PU=40kOhm"
io8p10_arsudq_ft  "SPEED10"
io8p11_arsudq_ft_pd  "SPEED11, PD=40kOhm"
io8p11_arsudq_ft_pu  "SPEED11, PU=40kOhm"
io8p11_arsudq_ft  "SPEED11"
[Model Selector] io8p_arsudq_ft_v33
io8p00_arsudq_ft_v33_pd_lv  "SPEED00 1P8V, PD=40kOhm"
io8p00_arsudq_ft_v33_pu_lv  "SPEED00 1P8V, PU=40kOhm"
io8p00_arsudq_ft_v33_lv  "SPEED00 1P8V"
io8p01_arsudq_ft_v33_pd_lv  "SPEED01 1P8V, PD=40kOhm"
io8p01_arsudq_ft_v33_pu_lv  "SPEED01 1P8V, PU=40kOhm"
io8p01_arsudq_ft_v33_lv  "SPEED01 1P8V"
io8p10_arsudq_ft_v33_pd_lv  "SPEED10 1P8V, PD=40kOhm"
io8p10_arsudq_ft_v33_pu_lv  "SPEED10 1P8V, PU=40kOhm"
io8p10_arsudq_ft_v33_lv  "SPEED10 1P8V"
io8p11_arsudq_ft_v33_pd_lv  "SPEED11 1P8V, PD=40kOhm"
io8p11_arsudq_ft_v33_pu_lv  "SPEED11 1P8V, PU=40kOhm"
io8p11_arsudq_ft_v33_lv  "SPEED11 1P8V"
io8p00_arsudq_ft_v33_pd  "SPEED00, PD=40kOhm"
io8p00_arsudq_ft_v33_pu  "SPEED00, PU=40kOhm"
io8p00_arsudq_ft_v33  "SPEED00"
io8p01_arsudq_ft_v33_pd  "SPEED01, PD=40kOhm"
io8p01_arsudq_ft_v33_pu  "SPEED01, PU=40kOhm"
io8p01_arsudq_ft_v33  "SPEED01"
io8p10_arsudq_ft_v33_pd  "SPEED10, PD=40kOhm"
io8p10_arsudq_ft_v33_pu  "SPEED10, PU=40kOhm"
io8p10_arsudq_ft_v33  "SPEED10"
io8p11_arsudq_ft_v33_pd  "SPEED11, PD=40kOhm"
io8p11_arsudq_ft_v33_pu  "SPEED11, PU=40kOhm"
io8p11_arsudq_ft_v33  "SPEED11"
[Model Selector] io8p_arsudq_i2cin_ft
io8p00_arsudq_i2cin_ft_pd_lv  "SPEED00 1P8V, PD=40kOhm"
io8p00_arsudq_i2cin_ft_pu_lv  "SPEED00 1P8V, PU=40kOhm"
io8p00_arsudq_i2cin_ft_lv  "SPEED00 1P8V"
io8p01_arsudq_i2cin_ft_pd_lv  "SPEED01 1P8V, PD=40kOhm"
io8p01_arsudq_i2cin_ft_pu_lv  "SPEED01 1P8V, PU=40kOhm"
io8p01_arsudq_i2cin_ft_lv  "SPEED01 1P8V"
io8p10_arsudq_i2cin_ft_pd_lv  "SPEED10 1P8V, PD=40kOhm"
io8p10_arsudq_i2cin_ft_pu_lv  "SPEED10 1P8V, PU=40kOhm"
io8p10_arsudq_i2cin_ft_lv  "SPEED10 1P8V"
io8p11_arsudq_i2cin_ft_pd_lv  "SPEED11 1P8V, PD=40kOhm"
io8p11_arsudq_i2cin_ft_pu_lv  "SPEED11 1P8V, PU=40kOhm"
io8p11_arsudq_i2cin_ft_lv  "SPEED11 1P8V"
io8p00_arsudq_i2cin_ft_pd  "SPEED00, PD=40kOhm"
io8p00_arsudq_i2cin_ft_pu  "SPEED00, PU=40kOhm"
io8p00_arsudq_i2cin_ft  "SPEED00"
io8p01_arsudq_i2cin_ft_pd  "SPEED01, PD=40kOhm"
io8p01_arsudq_i2cin_ft_pu  "SPEED01, PU=40kOhm"
io8p01_arsudq_i2cin_ft  "SPEED01"
io8p10_arsudq_i2cin_ft_pd  "SPEED10, PD=40kOhm"
io8p10_arsudq_i2cin_ft_pu  "SPEED10, PU=40kOhm"
io8p10_arsudq_i2cin_ft  "SPEED10"
io8p11_arsudq_i2cin_ft_pd  "SPEED11, PD=40kOhm"
io8p11_arsudq_i2cin_ft_pu  "SPEED11, PU=40kOhm"
io8p11_arsudq_i2cin_ft  "SPEED11"
[Model Selector] io8p_arwsudq_ft
io8p00_arwsudq_ft_pd_lv  "SPEED00 1P8V, PD=40kOhm"
io8p00_arwsudq_ft_pu_lv  "SPEED00 1P8V, PU=40kOhm"
io8p00_arwsudq_ft_lv  "SPEED00 1P8V"
io8p01_arwsudq_ft_pd_lv  "SPEED01 1P8V, PD=40kOhm"
io8p01_arwsudq_ft_pu_lv  "SPEED01 1P8V, PU=40kOhm"
io8p01_arwsudq_ft_lv  "SPEED01 1P8V"
io8p10_arwsudq_ft_pd_lv  "SPEED10 1P8V, PD=40kOhm"
io8p10_arwsudq_ft_pu_lv  "SPEED10 1P8V, PU=40kOhm"
io8p10_arwsudq_ft_lv  "SPEED10 1P8V"
io8p11_arwsudq_ft_pd_lv  "SPEED11 1P8V, PD=40kOhm"
io8p11_arwsudq_ft_pu_lv  "SPEED11 1P8V, PU=40kOhm"
io8p11_arwsudq_ft_lv  "SPEED11 1P8V"
io8p00_arwsudq_ft_pd  "SPEED00, PD=40kOhm"
io8p00_arwsudq_ft_pu  "SPEED00, PU=40kOhm"
io8p00_arwsudq_ft  "SPEED00"
io8p01_arwsudq_ft_pd  "SPEED01, PD=40kOhm"
io8p01_arwsudq_ft_pu  "SPEED01, PU=40kOhm"
io8p01_arwsudq_ft  "SPEED01"
io8p10_arwsudq_ft_pd  "SPEED10, PD=40kOhm"
io8p10_arwsudq_ft_pu  "SPEED10, PU=40kOhm"
io8p10_arwsudq_ft  "SPEED10"
io8p11_arwsudq_ft_pd  "SPEED11, PD=40kOhm"
io8p11_arwsudq_ft_pu  "SPEED11, PU=40kOhm"
io8p11_arwsudq_ft  "SPEED11"
[Model Selector] io8p_arwsudq_ft_v33
io8p00_arwsudq_ft_v33_pd_lv  "SPEED00 1P8V, PD=40kOhm"
io8p00_arwsudq_ft_v33_pu_lv  "SPEED00 1P8V, PU=40kOhm"
io8p00_arwsudq_ft_v33_lv  "SPEED00 1P8V"
io8p01_arwsudq_ft_v33_pd_lv  "SPEED01 1P8V, PD=40kOhm"
io8p01_arwsudq_ft_v33_pu_lv  "SPEED01 1P8V, PU=40kOhm"
io8p01_arwsudq_ft_v33_lv  "SPEED01 1P8V"
io8p10_arwsudq_ft_v33_pd_lv  "SPEED10 1P8V, PD=40kOhm"
io8p10_arwsudq_ft_v33_pu_lv  "SPEED10 1P8V, PU=40kOhm"
io8p10_arwsudq_ft_v33_lv  "SPEED10 1P8V"
io8p11_arwsudq_ft_v33_pd_lv  "SPEED11 1P8V, PD=40kOhm"
io8p11_arwsudq_ft_v33_pu_lv  "SPEED11 1P8V, PU=40kOhm"
io8p11_arwsudq_ft_v33_lv  "SPEED11 1P8V"
io8p00_arwsudq_ft_v33_pd  "SPEED00, PD=40kOhm"
io8p00_arwsudq_ft_v33_pu  "SPEED00, PU=40kOhm"
io8p00_arwsudq_ft_v33  "SPEED00"
io8p01_arwsudq_ft_v33_pd  "SPEED01, PD=40kOhm"
io8p01_arwsudq_ft_v33_pu  "SPEED01, PU=40kOhm"
io8p01_arwsudq_ft_v33  "SPEED01"
io8p10_arwsudq_ft_v33_pd  "SPEED10, PD=40kOhm"
io8p10_arwsudq_ft_v33_pu  "SPEED10, PU=40kOhm"
io8p10_arwsudq_ft_v33  "SPEED10"
io8p11_arwsudq_ft_v33_pd  "SPEED11, PD=40kOhm"
io8p11_arwsudq_ft_v33_pu  "SPEED11, PU=40kOhm"
io8p11_arwsudq_ft_v33  "SPEED11"
[Model Selector] io8usb_id_otg_ft
io8p00_id_otg_ft_pd_lv  "SPEED00 1P8V, PD=14kOhm"
io8p00_id_otg_ft_pu_lv  "SPEED00 1P8V, PU=14kOhm"
io8p00_id_otg_ft_lv  "SPEED00 1P8V"
io8p01_id_otg_ft_pd_lv  "SPEED01 1P8V, PD=14kOhm"
io8p01_id_otg_ft_pu_lv  "SPEED01 1P8V, PU=14kOhm"
io8p01_id_otg_ft_lv  "SPEED01 1P8V"
io8p10_id_otg_ft_pd_lv  "SPEED10 1P8V, PD=14kOhm"
io8p10_id_otg_ft_pu_lv  "SPEED10 1P8V, PU=14kOhm"
io8p10_id_otg_ft_lv  "SPEED10 1P8V"
io8p11_id_otg_ft_pd_lv  "SPEED11 1P8V, PD=14kOhm"
io8p11_id_otg_ft_pu_lv  "SPEED11 1P8V, PU=14kOhm"
io8p11_id_otg_ft_lv  "SPEED11 1P8V"
io8p00_id_otg_ft_pd  "SPEED00, PD=14kOhm"
io8p00_id_otg_ft_pu  "SPEED00, PU=14kOhm"
io8p00_id_otg_ft  "SPEED00"
io8p01_id_otg_ft_pd  "SPEED01, PD=14kOhm"
io8p01_id_otg_ft_pu  "SPEED01, PU=14kOhm"
io8p01_id_otg_ft  "SPEED01"
io8p10_id_otg_ft_pd  "SPEED10, PD=14kOhm"
io8p10_id_otg_ft_pu  "SPEED10, PU=14kOhm"
io8p10_id_otg_ft  "SPEED10"
io8p11_id_otg_ft_pd  "SPEED11, PD=14kOhm"
io8p11_id_otg_ft_pu  "SPEED11, PU=14kOhm"
io8p11_id_otg_ft  "SPEED11"
[Model Selector] io8usb_lsfs_otg_ft
io8usb_ls_otg_ft_dpdn_pd  "LS USB DP/DN IO + PD=20kOhm"
io8usb_ls_otg_ft_dpdn_pupu2  "LS USB DP/DN IO + PU/PU2=2.2kOhm"
io8usb_ls_otg_ft_dpdn_pu2  "LS USB DP/DN IO + PU2=1.2kOhm"
io8usb_ls_otg_ft_dpdn_pu  "LS USB DP/DN IO + PU=1.2kOhm"
io8usb_ls_otg_ft_dpdn  "LS USB DP/DN IO"
io8usb_fs_otg_ft_dpdn_pd  "HS USB DP/DN IO + PD=20kOhm"
io8usb_fs_otg_ft_dpdn_pupu2  "HS USB DP/DN IO + PU/PU2=2.2kOhm"
io8usb_fs_otg_ft_dpdn_pu2  "HS USB DP/DN IO + PU2=1.2kOhm"
io8usb_fs_otg_ft_dpdn_pu  "HS USB DP/DN IO + PU=1.2kOhm"
io8usb_fs_otg_ft_dpdn  "HS USB DP/DN IO"
io8p00_lsfs_otg_ft_pd_lv  "SPEED00 1P8V, PD=40kOhm"
io8p00_lsfs_otg_ft_pu_lv  "SPEED00 1P8V, PU=40kOhm"
io8p00_lsfs_otg_ft_lv  "SPEED00 1P8V"
io8p01_lsfs_otg_ft_pd_lv  "SPEED01 1P8V, PD=40kOhm"
io8p01_lsfs_otg_ft_pu_lv  "SPEED01 1P8V, PU=40kOhm"
io8p01_lsfs_otg_ft_lv  "SPEED01 1P8V"
io8p10_lsfs_otg_ft_pd_lv  "SPEED10 1P8V, PD=40kOhm"
io8p10_lsfs_otg_ft_pu_lv  "SPEED10 1P8V, PU=40kOhm"
io8p10_lsfs_otg_ft_lv  "SPEED10 1P8V"
io8p11_lsfs_otg_ft_pd_lv  "SPEED11 1P8V, PD=40kOhm"
io8p11_lsfs_otg_ft_pu_lv  "SPEED11 1P8V, PU=40kOhm"
io8p11_lsfs_otg_ft_lv  "SPEED11 1P8V"
io8p00_lsfs_otg_ft_pd  "SPEED00, PD=40kOhm"
io8p00_lsfs_otg_ft_pu  "SPEED00, PU=40kOhm"
io8p00_lsfs_otg_ft  "SPEED00"
io8p01_lsfs_otg_ft_pd  "SPEED01, PD=40kOhm"
io8p01_lsfs_otg_ft_pu  "SPEED01, PU=40kOhm"
io8p01_lsfs_otg_ft  "SPEED01"
io8p10_lsfs_otg_ft_pd  "SPEED10, PD=40kOhm"
io8p10_lsfs_otg_ft_pu  "SPEED10, PU=40kOhm"
io8p10_lsfs_otg_ft  "SPEED10"
io8p11_lsfs_otg_ft_pd  "SPEED11, PD=40kOhm"
io8p11_lsfs_otg_ft_pu  "SPEED11, PU=40kOhm"
io8p11_lsfs_otg_ft  "SPEED11"
[Model Selector] io8usb_vbus_otg_ft
io8psenb_vbus_otg_ft  "VBUS PULSE, SENSE VB"
io8psenab_vbus_otg_ft  "VBUS PULSE, SENSE VA and VB"
io8psena_vbus_otg_ft  "VBUS PULSE, SENSE VA"
io8psen_vbus_otg_ft  "VBUS PULSE"
io8p00_vbus_otg_ft_pd_lv  "SPEED00 1P8V, PD=40kOhm"
io8p00_vbus_otg_ft_pu_lv  "SPEED00 1P8V, PU=40kOhm"
io8p00_vbus_otg_ft_lv  "SPEED00 1P8V"
io8p01_vbus_otg_ft_pd_lv  "SPEED01 1P8V, PD=40kOhm"
io8p01_vbus_otg_ft_pu_lv  "SPEED01 1P8V, PU=40kOhm"
io8p01_vbus_otg_ft_lv  "SPEED01 1P8V"
io8p10_vbus_otg_ft_pd_lv  "SPEED10 1P8V, PD=40kOhm"
io8p10_vbus_otg_ft_pu_lv  "SPEED10 1P8V, PU=40kOhm"
io8p10_vbus_otg_ft_lv  "SPEED10 1P8V"
io8p11_vbus_otg_ft_pd_lv  "SPEED11 1P8V, PD=40kOhm"
io8p11_vbus_otg_ft_pu_lv  "SPEED11 1P8V, PU=40kOhm"
io8p11_vbus_otg_ft_lv  "SPEED11 1P8V"
io8p00_vbus_otg_ft_pd  "SPEED00, PD=40kOhm"
io8p00_vbus_otg_ft_pu  "SPEED00, PU=40kOhm"
io8p00_vbus_otg_ft  "SPEED00"
io8p01_vbus_otg_ft_pd  "SPEED01, PD=40kOhm"
io8p01_vbus_otg_ft_pu  "SPEED01, PU=40kOhm"
io8p01_vbus_otg_ft  "SPEED01"
io8p10_vbus_otg_ft_pd  "SPEED10, PD=40kOhm"
io8p10_vbus_otg_ft_pu  "SPEED10, PU=40kOhm"
io8p10_vbus_otg_ft  "SPEED10"
io8p11_vbus_otg_ft_pd  "SPEED11, PD=40kOhm"
io8p11_vbus_otg_ft_pu  "SPEED11, PU=40kOhm"
io8p11_vbus_otg_ft  "SPEED11"
[Model Selector] ioreset_ft_v33
ioreset_ft_v33_pu_lv  "ioreset 1P8V + PU=40kOhm"
ioreset_ft_v33_nopu_lv  "ioreset 1P8V"
ioreset_ft_v33_pu  "ioreset + PU=40kOhm"
ioreset_ft_v33_nopu  "ioreset"
[Model Selector] vpp_test_hv
vpp_test_hv_2p4  "Input Buffer 1P8V"
vpp_test_hv_3p3  "Input Buffer"
| Models and submodels in the file (260): io8p00_ar3wsudq_ft_pd_lv (I/O), io8p00_ar3wsudq_ft_pu_lv (I/O), io8p00_ar3wsudq_ft_lv (I/O), io8p01_ar3wsudq_ft_pd_lv (I/O), io8p01_ar3wsudq_ft_pu_lv (I/O), io8p01_ar3wsudq_ft_lv (I/O), io8p10_ar3wsudq_ft_pd_lv (I/O), io8p10_ar3wsudq_ft_pu_lv (I/O), io8p10_ar3wsudq_ft_lv (I/O), io8p11_ar3wsudq_ft_pd_lv (I/O), io8p11_ar3wsudq_ft_pu_lv (I/O), io8p11_ar3wsudq_ft_lv (I/O), io8p00_ar3wsudq_ft_pd (I/O), io8p00_ar3wsudq_ft_pu (I/O), io8p00_ar3wsudq_ft (I/O), io8p01_ar3wsudq_ft_pd (I/O), io8p01_ar3wsudq_ft_pu (I/O), io8p01_ar3wsudq_ft (I/O), io8p10_ar3wsudq_ft_pd (I/O), io8p10_ar3wsudq_ft_pu (I/O), io8p10_ar3wsudq_ft (I/O), io8p11_ar3wsudq_ft_pd (I/O), io8p11_ar3wsudq_ft_pu (I/O), io8p11_ar3wsudq_ft (I/O), io8p00_ar3wsudq_ft_v33_pd_lv (I/O), io8p00_ar3wsudq_ft_v33_pu_lv (I/O), io8p00_ar3wsudq_ft_v33_lv (I/O), io8p01_ar3wsudq_ft_v33_pd_lv (I/O), io8p01_ar3wsudq_ft_v33_pu_lv (I/O), io8p01_ar3wsudq_ft_v33_lv (I/O), io8p10_ar3wsudq_ft_v33_pd_lv (I/O), io8p10_ar3wsudq_ft_v33_pu_lv (I/O), io8p10_ar3wsudq_ft_v33_lv (I/O), io8p11_ar3wsudq_ft_v33_pd_lv (I/O), io8p11_ar3wsudq_ft_v33_pu_lv (I/O), io8p11_ar3wsudq_ft_v33_lv (I/O), io8p00_ar3wsudq_ft_v33_pd (I/O), io8p00_ar3wsudq_ft_v33_pu (I/O), io8p00_ar3wsudq_ft_v33 (I/O), io8p01_ar3wsudq_ft_v33_pd (I/O), io8p01_ar3wsudq_ft_v33_pu (I/O), io8p01_ar3wsudq_ft_v33 (I/O), io8p10_ar3wsudq_ft_v33_pd (I/O), io8p10_ar3wsudq_ft_v33_pu (I/O), io8p10_ar3wsudq_ft_v33 (I/O), io8p11_ar3wsudq_ft_v33_pd (I/O), io8p11_ar3wsudq_ft_v33_pu (I/O), io8p11_ar3wsudq_ft_v33 (I/O), io8p00_arsudq_ft_pd_lv (I/O), io8p00_arsudq_ft_pu_lv (I/O), io8p00_arsudq_ft_lv (I/O), io8p01_arsudq_ft_pd_lv (I/O), io8p01_arsudq_ft_pu_lv (I/O), io8p01_arsudq_ft_lv (I/O), io8p10_arsudq_ft_pd_lv (I/O), io8p10_arsudq_ft_pu_lv (I/O), io8p10_arsudq_ft_lv (I/O), io8p11_arsudq_ft_pd_lv (I/O), io8p11_arsudq_ft_pu_lv (I/O), io8p11_arsudq_ft_lv (I/O), io8p00_arsudq_ft_pd (I/O), io8p00_arsudq_ft_pu (I/O), io8p00_arsudq_ft (I/O), io8p01_arsudq_ft_pd (I/O), io8p01_arsudq_ft_pu (I/O), io8p01_arsudq_ft (I/O), io8p10_arsudq_ft_pd (I/O), io8p10_arsudq_ft_pu (I/O), io8p10_arsudq_ft (I/O), io8p11_arsudq_ft_pd (I/O), io8p11_arsudq_ft_pu (I/O), io8p11_arsudq_ft (I/O), io8p00_arsudq_ft_v33_pd_lv (I/O), io8p00_arsudq_ft_v33_pu_lv (I/O), io8p00_arsudq_ft_v33_lv (I/O), io8p01_arsudq_ft_v33_pd_lv (I/O), io8p01_arsudq_ft_v33_pu_lv (I/O), io8p01_arsudq_ft_v33_lv (I/O), io8p10_arsudq_ft_v33_pd_lv (I/O), io8p10_arsudq_ft_v33_pu_lv (I/O)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
