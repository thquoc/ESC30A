|   stm32f405_415_407_417_lqfp144 IBIS Model
[IBIS ver]   4.2
[File name]  stm32f405_415_407_417_lqfp144.ibs
[File Rev]   1.3
[Date]   05-30-2014
[Source] Data Created at STMicroelectronics
[Notes]   File originated from ELDO simulations.
[Disclaimer]  This information is for modeling purpose only and is
   not guaranted. The information is subject to change without
   notice.
[Copyright] Copyright 2013 STMicroelectronics Inc.
[Component] stm32f405_415_407_417_lqfp144
[Manufacturer] STMicroelectronics
[Package]
| variable   typ   min   max
R_pkg   0.0   NA   NA
L_pkg   0.0H   NA   NA
C_pkg   0.0F   NA   NA
[Pin]   signal_name   model_name   R_pin   L_pin   C_pin
1   PE2   io8p_arsudq_ft   1.876E-01   9.420E-09   2.67867E-13
2   PE3   io8p_arsudq_ft   1.824E-01   9.060E-09   2.43844E-13
3   PE4   io8p_arsudq_ft   1.776E-01   8.721E-09   2.21277E-13
4   PE5   io8p_arsudq_ft   1.731E-01   8.405E-09   2.00166E-13
5   PE6   io8p_arsudq_ft   1.689E-01   8.110E-09   1.80511E-13
6   VBAT   POWER   1.650E-01   7.837E-09   1.62311E-13
7   PC13   io8p_arwsudq_ft_v33   1.615E-01   7.586E-09   1.45568E-13
8   PC14   io8p_arwsudq_ft   1.582E-01   7.357E-09   1.30281E-13
9   PC15   io8p_arsudq_ft   1.552E-01   7.150E-09   1.16449E-13
10   PF0   io8p_arsudq_i2cin_ft   1.526E-01   6.964E-09   1.04074E-13
11   PF1   io8p_arsudq_i2cin_ft   1.503E-01   6.801E-09   9.31542E-14
12   PF2   io8p_arsudq_ft   1.482E-01   6.659E-09   8.36906E-14
13   PF3   io8p_arwsudq_ft   1.465E-01   6.539E-09   7.56829E-14
14   PF4   io8p_arwsudq_ft   1.451E-01   6.440E-09   6.91312E-14
15   PF5   io8p_arwsudq_ft   1.441E-01   6.364E-09   6.40354E-14
16   VSS   GND   1.433E-01   6.309E-09   6.03955E-14
17   VDD   POWER   1.428E-01   6.277E-09   5.82116E-14
18   PF6   io8p_arwsudq_ft   1.427E-01   6.266E-09   5.74836E-14
19   PF7   io8p_arwsudq_ft   1.427E-01   6.266E-09   5.74836E-14
20   PF8   io8p_arwsudq_ft   1.428E-01   6.277E-09   5.82116E-14
21   PF9   io8p_arwsudq_ft   1.433E-01   6.309E-09   6.03955E-14
22   PF10   io8p_arwsudq_ft   1.441E-01   6.364E-09   6.40354E-14
23   PH0   io8p_arsudq_ft   1.451E-01   6.440E-09   6.91312E-14
24   PH1   io8p_arsudq_ft   1.465E-01   6.539E-09   7.56829E-14
25   NRST   ioreset_ft_v33   1.482E-01   6.659E-09   8.36906E-14
26   PC0   io8p_ar3wsudq_ft   1.503E-01   6.801E-09   9.31542E-14
27   PC1   io8p_ar3wsudq_ft   1.526E-01   6.964E-09   1.04074E-13
28   PC2   io8p_ar3wsudq_ft   1.552E-01   7.150E-09   1.16449E-13
29   PC3   io8p_ar3wsudq_ft   1.582E-01   7.357E-09   1.30281E-13
30   VDD   POWER   1.615E-01   7.586E-09   1.45568E-13
31   VREFM   POWER   1.650E-01   7.837E-09   1.62311E-13
32   VREFP   POWER   1.689E-01   8.110E-09   1.80511E-13
33   VDDA   POWER   1.731E-01   8.405E-09   2.00166E-13
34   PA0   io8p_ar3wsudq_ft_v33   1.776E-01   8.721E-09   2.21277E-13
35   PA1   io8p_ar3wsudq_ft   1.824E-01   9.060E-09   2.43844E-13
36   PA2   io8p_ar3wsudq_ft   1.876E-01   9.420E-09   2.67867E-13
37   PA3   io8p_ar3wsudq_ft   1.876E-01   9.420E-09   2.67867E-13
38   BYPASS_REG   io8p_arsudq_ft_v33   1.824E-01   9.060E-09   2.43844E-13
39   VDD   POWER   1.776E-01   8.721E-09   2.21277E-13
40   PA4   io8p_ar3wsudq_ft   1.731E-01   8.405E-09   2.00166E-13
41   PA5   io8p_ar3wsudq_ft   1.689E-01   8.110E-09   1.80511E-13
42   PA6   io8p_ar3wsudq_ft   1.650E-01   7.837E-09   1.62311E-13
43   PA7   io8p_ar3wsudq_ft   1.615E-01   7.586E-09   1.45568E-13
44   PC4   io8p_ar3wsudq_ft   1.582E-01   7.357E-09   1.30281E-13
45   PC5   io8p_ar3wsudq_ft   1.552E-01   7.150E-09   1.16449E-13
46   PB0   io8p_ar3wsudq_ft   1.526E-01   6.964E-09   1.04074E-13
47   PB1   io8p_ar3wsudq_ft   1.503E-01   6.801E-09   9.31542E-14
48   PB2   io8p_ar3wsudq_ft   1.482E-01   6.659E-09   8.36906E-14
49   PF11   io8p_arsudq_ft   1.465E-01   6.539E-09   7.56829E-14
50   PF12   io8p_arsudq_ft   1.451E-01   6.440E-09   6.91312E-14
51   VSS   GND   1.441E-01   6.364E-09   6.40354E-14
52   VDD   POWER   1.433E-01   6.309E-09   6.03955E-14
53   PF13   io8p_arsudq_ft   1.428E-01   6.277E-09   5.82116E-14
54   PF14   io8p_arsudq_ft   1.427E-01   6.266E-09   5.74836E-14
55   PF15   io8p_arsudq_ft   1.427E-01   6.266E-09   5.74836E-14
56   PG0   io8p_arsudq_ft   1.428E-01   6.277E-09   5.82116E-14
57   PG1   io8p_arsudq_ft   1.433E-01   6.309E-09   6.03955E-14
58   PE7   io8p_arsudq_ft   1.441E-01   6.364E-09   6.40354E-14
59   PE8   io8p_arsudq_ft   1.451E-01   6.440E-09   6.91312E-14
60   PE9   io8p_arsudq_ft   1.465E-01   6.539E-09   7.56829E-14
61   VSS   GND   1.482E-01   6.659E-09   8.36906E-14
62   VDD   POWER   1.503E-01   6.801E-09   9.31542E-14
63   PE10   io8p_arsudq_ft   1.526E-01   6.964E-09   1.04074E-13
64   PE11   io8p_arsudq_ft   1.552E-01   7.150E-09   1.16449E-13
65   PE12   io8p_arsudq_ft   1.582E-01   7.357E-09   1.30281E-13
66   PE13   io8p_arsudq_ft   1.615E-01   7.586E-09   1.45568E-13
67   PE14   io8p_arsudq_ft   1.650E-01   7.837E-09   1.62311E-13
68   PE15   io8p_ar3wsudq_ft   1.689E-01   8.110E-09   1.80511E-13
69   PB10   io8p_arsudq_i2cin_ft   1.731E-01   8.405E-09   2.00166E-13
70   PB11   io8p_arsudq_i2cin_ft   1.776E-01   8.721E-09   2.21277E-13
71   VCAP1   POWER   1.824E-01   9.060E-09   2.43844E-13
72   VDD   POWER   1.876E-01   9.420E-09   2.67867E-13
73   PB12   io8usb_id_otg_ft   1.876E-01   9.420E-09   2.67867E-13
74   PB13   io8usb_vbus_otg_ft   1.824E-01   9.060E-09   2.43844E-13
75   PB14   io8usb_lsfs_otg_ft   1.776E-01   8.721E-09   2.21277E-13
76   PB15   io8usb_lsfs_otg_ft   1.731E-01   8.405E-09   2.00166E-13
77   PD8   io8p_arsudq_ft   1.689E-01   8.110E-09   1.80511E-13
78   PD9   io8p_arsudq_ft   1.650E-01   7.837E-09   1.62311E-13
79   PD10   io8p_arsudq_ft   1.615E-01   7.586E-09   1.45568E-13
80   PD11   io8p_arsudq_ft   1.582E-01   7.357E-09   1.30281E-13
81   PD12   io8p_arsudq_ft   1.552E-01   7.150E-09   1.16449E-13
82   PD13   io8p_arsudq_ft   1.526E-01   6.964E-09   1.04074E-13
83   VSS   GND   1.503E-01   6.801E-09   9.31542E-14
84   VDD   POWER   1.482E-01   6.659E-09   8.36906E-14
85   PD14   io8p_arsudq_ft   1.465E-01   6.539E-09   7.56829E-14
86   PD15   io8p_arsudq_ft   1.451E-01   6.440E-09   6.91312E-14
87   PG2   io8p_arsudq_ft   1.441E-01   6.364E-09   6.40354E-14
88   PG3   io8p_arsudq_ft   1.433E-01   6.309E-09   6.03955E-14
89   PG4   io8p_arsudq_ft   1.428E-01   6.277E-09   5.82116E-14
90   PG5   io8p_arsudq_ft   1.427E-01   6.266E-09   5.74836E-14
91   PG6   io8p_arsudq_ft   1.427E-01   6.266E-09   5.74836E-14
92   PG7   io8p_arsudq_ft   1.428E-01   6.277E-09   5.82116E-14
93   PG8   io8p_arsudq_ft   1.433E-01   6.309E-09   6.03955E-14
94   VSS   GND   1.441E-01   6.364E-09   6.40354E-14
95   VDD   POWER   1.451E-01   6.440E-09   6.91312E-14
96   PC6   io8p_arsudq_ft   1.465E-01   6.539E-09   7.56829E-14
97   PC7   io8p_arsudq_ft   1.482E-01   6.659E-09   8.36906E-14
98   PC8   io8p_arsudq_ft   1.503E-01   6.801E-09   9.31542E-14
99   PC9   io8p_arsudq_i2cin_ft   1.526E-01   6.964E-09   1.04074E-13
100   PA8   io8p_arsudq_i2cin_ft   1.552E-01   7.150E-09   1.16449E-13
101   PA9   io8usb_vbus_otg_ft   1.582E-01   7.357E-09   1.30281E-13
102   PA10   io8usb_id_otg_ft   1.615E-01   7.586E-09   1.45568E-13
103   PA11   io8usb_lsfs_otg_ft   1.650E-01   7.837E-09   1.62311E-13
104   PA12   io8usb_lsfs_otg_ft   1.689E-01   8.110E-09   1.80511E-13
105   PA13   io8p_arsudq_ft   1.731E-01   8.405E-09   2.00166E-13
106   VCAP2   POWER   1.776E-01   8.721E-09   2.21277E-13
107   VSS   GND   1.824E-01   9.060E-09   2.43844E-13
108   VDD   POWER   1.876E-01   9.420E-09   2.67867E-13
109   PA14   io8p_arsudq_ft   1.876E-01   9.420E-09   2.67867E-13
110   PA15   io8p_arsudq_ft   1.824E-01   9.060E-09   2.43844E-13
111   PC10   io8p_arsudq_ft   1.776E-01   8.721E-09   2.21277E-13
112   PC11   io8p_arsudq_ft   1.731E-01   8.405E-09   2.00166E-13
113   PC12   io8p_arsudq_ft   1.689E-01   8.110E-09   1.80511E-13
114   PD0   io8p_arsudq_ft   1.650E-01   7.837E-09   1.62311E-13
115   PD1   io8p_arsudq_ft   1.615E-01   7.586E-09   1.45568E-13
116   PD2   io8p_arsudq_ft   1.582E-01   7.357E-09   1.30281E-13
117   PD3   io8p_arsudq_ft   1.552E-01   7.150E-09   1.16449E-13
118   PD4   io8p_arsudq_ft   1.526E-01   6.964E-09   1.04074E-13
119   PD5   io8p_arsudq_ft   1.503E-01   6.801E-09   9.31542E-14
120   VSS   GND   1.482E-01   6.659E-09   8.36906E-14
121   VDD   POWER   1.465E-01   6.539E-09   7.56829E-14
122   PD6   io8p_arsudq_ft   1.451E-01   6.440E-09   6.91312E-14
123   PD7   io8p_arsudq_ft   1.441E-01   6.364E-09   6.40354E-14
124   PG9   io8p_arsudq_ft   1.433E-01   6.309E-09   6.03955E-14
125   PG10   io8p_arsudq_ft   1.428E-01   6.277E-09   5.82116E-14
126   PG11   io8p_arsudq_ft   1.427E-01   6.266E-09   5.74836E-14
127   PG12   io8p_arsudq_ft   1.427E-01   6.266E-09   5.74836E-14
128   PG13   io8p_arsudq_ft   1.428E-01   6.277E-09   5.82116E-14
129   PG14   io8p_arsudq_ft   1.433E-01   6.309E-09   6.03955E-14
130   VSS   GND   1.441E-01   6.364E-09   6.40354E-14
131   VDD   POWER   1.451E-01   6.440E-09   6.91312E-14
132   PG15   io8p_arsudq_ft   1.465E-01   6.539E-09   7.56829E-14
133   PB3   io8p_arsudq_ft   1.482E-01   6.659E-09   8.36906E-14
134   PB4   io8p_arsudq_ft   1.503E-01   6.801E-09   9.31542E-14
135   PB5   io8p_ar3wsudq_ft   1.526E-01   6.964E-09   1.04074E-13
136   PB6   io8p_arsudq_i2cin_ft   1.552E-01   7.150E-09   1.16449E-13
137   PB7   io8p_arsudq_i2cin_ft   1.582E-01   7.357E-09   1.30281E-13
138   BOOT0   vpp_test_hv   1.615E-01   7.586E-09   1.45568E-13
139   PB8   io8p_arsudq_i2cin_ft   1.650E-01   7.837E-09   1.62311E-13
140   PB9   io8p_arsudq_i2cin_ft   1.689E-01   8.110E-09   1.80511E-13
141   PE0   io8p_arsudq_ft   1.731E-01   8.405E-09   2.00166E-13
142   PE1   io8p_arsudq_ft   1.776E-01   8.721E-09   2.21277E-13
143   PDR_ON   io8p_arsudq_ft_v33   1.824E-01   9.060E-09   2.43844E-13
144   VDD   POWER   1.876E-01   9.420E-09   2.67867E-13
[Diff Pin]   inv_pin   vdiff   tdelay_typ  tdelay_min  tdelay_max
75   76   200mV   NA   NA   NA
104   103   200mV   NA   NA   NA
[Model Selector] io8p_ar3wsudq_ft
io8p00_ar3wsudq_ft_pd_lv  "SPEED00 1P8V, PD=40kOhm"
io8p00_ar3wsudq_ft_pu_lv  "SPEED00 1P8V, PU=40kOhm"
io8p00_ar3wsudq_ft_lv  "SPEED00 1P8V"
io8p01_ar3wsudq_ft_pd_lv  "SPEED01 1P8V, PD=40kOhm"
io8p01_ar3wsudq_ft_pu_lv  "SPEED01 1P8V, PU=40kOhm"
io8p01_ar3wsudq_ft_lv  "SPEED01 1P8V"
io8p10_ar3wsudq_ft_pd_lv  "SPEED10 1P8V, PD=40kOhm"
io8p10_ar3wsudq_ft_pu_lv  "SPEED10 1P8V, PU=40kOhm"
io8p10_ar3wsudq_ft_lv  "SPEED10 1P8V"
io8p11_ar3wsudq_ft_pd_lv  "SPEED11 1P8V, PD=40kOhm"
io8p11_ar3wsudq_ft_pu_lv  "SPEED11 1P8V, PU=40kOhm"
io8p11_ar3wsudq_ft_lv  "SPEED11 1P8V"
io8p00_ar3wsudq_ft_pd  "SPEED00, PD=40kOhm"
io8p00_ar3wsudq_ft_pu  "SPEED00, PU=40kOhm"
io8p00_ar3wsudq_ft  "SPEED00"
io8p01_ar3wsudq_ft_pd  "SPEED01, PD=40kOhm"
io8p01_ar3wsudq_ft_pu  "SPEED01, PU=40kOhm"
io8p01_ar3wsudq_ft  "SPEED01"
io8p10_ar3wsudq_ft_pd  "SPEED10, PD=40kOhm"
io8p10_ar3wsudq_ft_pu  "SPEED10, PU=40kOhm"
io8p10_ar3wsudq_ft  "SPEED10"
io8p11_ar3wsudq_ft_pd  "SPEED11, PD=40kOhm"
io8p11_ar3wsudq_ft_pu  "SPEED11, PU=40kOhm"
io8p11_ar3wsudq_ft  "SPEED11"
[Model Selector] io8p_ar3wsudq_ft_v33
io8p00_ar3wsudq_ft_v33_pd_lv  "SPEED00 1P8V, PD=40kOhm"
io8p00_ar3wsudq_ft_v33_pu_lv  "SPEED00 1P8V, PU=40kOhm"
io8p00_ar3wsudq_ft_v33_lv  "SPEED00 1P8V"
io8p01_ar3wsudq_ft_v33_pd_lv  "SPEED01 1P8V, PD=40kOhm"
io8p01_ar3wsudq_ft_v33_pu_lv  "SPEED01 1P8V, PU=40kOhm"
io8p01_ar3wsudq_ft_v33_lv  "SPEED01 1P8V"
io8p10_ar3wsudq_ft_v33_pd_lv  "SPEED10 1P8V, PD=40kOhm"
io8p10_ar3wsudq_ft_v33_pu_lv  "SPEED10 1P8V, PU=40kOhm"
io8p10_ar3wsudq_ft_v33_lv  "SPEED10 1P8V"
io8p11_ar3wsudq_ft_v33_pd_lv  "SPEED11 1P8V, PD=40kOhm"
io8p11_ar3wsudq_ft_v33_pu_lv  "SPEED11 1P8V, PU=40kOhm"
io8p11_ar3wsudq_ft_v33_lv  "SPEED11 1P8V"
io8p00_ar3wsudq_ft_v33_pd  "SPEED00, PD=40kOhm"
io8p00_ar3wsudq_ft_v33_pu  "SPEED00, PU=40kOhm"
io8p00_ar3wsudq_ft_v33  "SPEED00"
io8p01_ar3wsudq_ft_v33_pd  "SPEED01, PD=40kOhm"
io8p01_ar3wsudq_ft_v33_pu  "SPEED01, PU=40kOhm"
io8p01_ar3wsudq_ft_v33  "SPEED01"
io8p10_ar3wsudq_ft_v33_pd  "SPEED10, PD=40kOhm"
io8p10_ar3wsudq_ft_v33_pu  "SPEED10, PU=40kOhm"
io8p10_ar3wsudq_ft_v33  "SPEED10"
io8p11_ar3wsudq_ft_v33_pd  "SPEED11, PD=40kOhm"
io8p11_ar3wsudq_ft_v33_pu  "SPEED11, PU=40kOhm"
io8p11_ar3wsudq_ft_v33  "SPEED11"
[Model Selector] io8p_arsudq_ft
io8p00_arsudq_ft_pd_lv  "SPEED00 1P8V, PD=40kOhm"
io8p00_arsudq_ft_pu_lv  "SPEED00 1P8V, PU=40kOhm"
io8p00_arsudq_ft_lv  "SPEED00 1P8V"
io8p01_arsudq_ft_pd_lv  "SPEED01 1P8V, PD=40kOhm"
io8p01_arsudq_ft_pu_lv  "SPEED01 1P8V, PU=40kOhm"
io8p01_arsudq_ft_lv  "SPEED01 1P8V"
io8p10_arsudq_ft_pd_lv  "SPEED10 1P8V, PD=40kOhm"
io8p10_arsudq_ft_pu_lv  "SPEED10 1P8V, PU=40kOhm"
io8p10_arsudq_ft_lv  "SPEED10 1P8V"
io8p11_arsudq_ft_pd_lv  "SPEED11 1P8V, PD=40kOhm"
io8p11_arsudq_ft_pu_lv  "SPEED11 1P8V, PU=40kOhm"
io8p11_arsudq_ft_lv  "SPEED11 1P8V"
io8p00_arsudq_ft_pd  "SPEED00, PD=40kOhm"
io8p00_arsudq_ft_pu  "SPEED00, PU=40kOhm"
io8p00_arsudq_ft  "SPEED00"
io8p01_arsudq_ft_pd  "SPEED01, PD=40kOhm"
io8p01_arsudq_ft_pu  "SPEED01, PU=40kOhm"
io8p01_arsudq_ft  "SPEED01"
io8p10_arsudq_ft_pd  "SPEED10, PD=40kOhm"
io8p10_arsudq_ft_pu  "SPEED10, PU=40kOhm"
io8p10_arsudq_ft  "SPEED10"
io8p11_arsudq_ft_pd  "SPEED11, PD=40kOhm"
io8p11_arsudq_ft_pu  "SPEED11, PU=40kOhm"
io8p11_arsudq_ft  "SPEED11"
[Model Selector] io8p_arsudq_ft_v33
io8p00_arsudq_ft_v33_pd_lv  "SPEED00 1P8V, PD=40kOhm"
io8p00_arsudq_ft_v33_pu_lv  "SPEED00 1P8V, PU=40kOhm"
io8p00_arsudq_ft_v33_lv  "SPEED00 1P8V"
io8p01_arsudq_ft_v33_pd_lv  "SPEED01 1P8V, PD=40kOhm"
io8p01_arsudq_ft_v33_pu_lv  "SPEED01 1P8V, PU=40kOhm"
io8p01_arsudq_ft_v33_lv  "SPEED01 1P8V"
io8p10_arsudq_ft_v33_pd_lv  "SPEED10 1P8V, PD=40kOhm"
io8p10_arsudq_ft_v33_pu_lv  "SPEED10 1P8V, PU=40kOhm"
io8p10_arsudq_ft_v33_lv  "SPEED10 1P8V"
io8p11_arsudq_ft_v33_pd_lv  "SPEED11 1P8V, PD=40kOhm"
io8p11_arsudq_ft_v33_pu_lv  "SPEED11 1P8V, PU=40kOhm"
io8p11_arsudq_ft_v33_lv  "SPEED11 1P8V"
io8p00_arsudq_ft_v33_pd  "SPEED00, PD=40kOhm"
io8p00_arsudq_ft_v33_pu  "SPEED00, PU=40kOhm"
io8p00_arsudq_ft_v33  "SPEED00"
io8p01_arsudq_ft_v33_pd  "SPEED01, PD=40kOhm"
io8p01_arsudq_ft_v33_pu  "SPEED01, PU=40kOhm"
io8p01_arsudq_ft_v33  "SPEED01"
io8p10_arsudq_ft_v33_pd  "SPEED10, PD=40kOhm"
io8p10_arsudq_ft_v33_pu  "SPEED10, PU=40kOhm"
io8p10_arsudq_ft_v33  "SPEED10"
io8p11_arsudq_ft_v33_pd  "SPEED11, PD=40kOhm"
io8p11_arsudq_ft_v33_pu  "SPEED11, PU=40kOhm"
io8p11_arsudq_ft_v33  "SPEED11"
[Model Selector] io8p_arsudq_i2cin_ft
io8p00_arsudq_i2cin_ft_pd_lv  "SPEED00 1P8V, PD=40kOhm"
io8p00_arsudq_i2cin_ft_pu_lv  "SPEED00 1P8V, PU=40kOhm"
io8p00_arsudq_i2cin_ft_lv  "SPEED00 1P8V"
io8p01_arsudq_i2cin_ft_pd_lv  "SPEED01 1P8V, PD=40kOhm"
io8p01_arsudq_i2cin_ft_pu_lv  "SPEED01 1P8V, PU=40kOhm"
io8p01_arsudq_i2cin_ft_lv  "SPEED01 1P8V"
io8p10_arsudq_i2cin_ft_pd_lv  "SPEED10 1P8V, PD=40kOhm"
io8p10_arsudq_i2cin_ft_pu_lv  "SPEED10 1P8V, PU=40kOhm"
io8p10_arsudq_i2cin_ft_lv  "SPEED10 1P8V"
io8p11_arsudq_i2cin_ft_pd_lv  "SPEED11 1P8V, PD=40kOhm"
io8p11_arsudq_i2cin_ft_pu_lv  "SPEED11 1P8V, PU=40kOhm"
io8p11_arsudq_i2cin_ft_lv  "SPEED11 1P8V"
io8p00_arsudq_i2cin_ft_pd  "SPEED00, PD=40kOhm"
io8p00_arsudq_i2cin_ft_pu  "SPEED00, PU=40kOhm"
io8p00_arsudq_i2cin_ft  "SPEED00"
io8p01_arsudq_i2cin_ft_pd  "SPEED01, PD=40kOhm"
io8p01_arsudq_i2cin_ft_pu  "SPEED01, PU=40kOhm"
io8p01_arsudq_i2cin_ft  "SPEED01"
io8p10_arsudq_i2cin_ft_pd  "SPEED10, PD=40kOhm"
io8p10_arsudq_i2cin_ft_pu  "SPEED10, PU=40kOhm"
io8p10_arsudq_i2cin_ft  "SPEED10"
io8p11_arsudq_i2cin_ft_pd  "SPEED11, PD=40kOhm"
io8p11_arsudq_i2cin_ft_pu  "SPEED11, PU=40kOhm"
io8p11_arsudq_i2cin_ft  "SPEED11"
[Model Selector] io8p_arwsudq_ft
io8p00_arwsudq_ft_pd_lv  "SPEED00 1P8V, PD=40kOhm"
io8p00_arwsudq_ft_pu_lv  "SPEED00 1P8V, PU=40kOhm"
io8p00_arwsudq_ft_lv  "SPEED00 1P8V"
io8p01_arwsudq_ft_pd_lv  "SPEED01 1P8V, PD=40kOhm"
io8p01_arwsudq_ft_pu_lv  "SPEED01 1P8V, PU=40kOhm"
io8p01_arwsudq_ft_lv  "SPEED01 1P8V"
io8p10_arwsudq_ft_pd_lv  "SPEED10 1P8V, PD=40kOhm"
io8p10_arwsudq_ft_pu_lv  "SPEED10 1P8V, PU=40kOhm"
io8p10_arwsudq_ft_lv  "SPEED10 1P8V"
io8p11_arwsudq_ft_pd_lv  "SPEED11 1P8V, PD=40kOhm"
io8p11_arwsudq_ft_pu_lv  "SPEED11 1P8V, PU=40kOhm"
io8p11_arwsudq_ft_lv  "SPEED11 1P8V"
io8p00_arwsudq_ft_pd  "SPEED00, PD=40kOhm"
io8p00_arwsudq_ft_pu  "SPEED00, PU=40kOhm"
io8p00_arwsudq_ft  "SPEED00"
io8p01_arwsudq_ft_pd  "SPEED01, PD=40kOhm"
io8p01_arwsudq_ft_pu  "SPEED01, PU=40kOhm"
io8p01_arwsudq_ft  "SPEED01"
io8p10_arwsudq_ft_pd  "SPEED10, PD=40kOhm"
io8p10_arwsudq_ft_pu  "SPEED10, PU=40kOhm"
io8p10_arwsudq_ft  "SPEED10"
io8p11_arwsudq_ft_pd  "SPEED11, PD=40kOhm"
io8p11_arwsudq_ft_pu  "SPEED11, PU=40kOhm"
io8p11_arwsudq_ft  "SPEED11"
[Model Selector] io8p_arwsudq_ft_v33
io8p00_arwsudq_ft_v33_pd_lv  "SPEED00 1P8V, PD=40kOhm"
io8p00_arwsudq_ft_v33_pu_lv  "SPEED00 1P8V, PU=40kOhm"
io8p00_arwsudq_ft_v33_lv  "SPEED00 1P8V"
io8p01_arwsudq_ft_v33_pd_lv  "SPEED01 1P8V, PD=40kOhm"
io8p01_arwsudq_ft_v33_pu_lv  "SPEED01 1P8V, PU=40kOhm"
io8p01_arwsudq_ft_v33_lv  "SPEED01 1P8V"
io8p10_arwsudq_ft_v33_pd_lv  "SPEED10 1P8V, PD=40kOhm"
io8p10_arwsudq_ft_v33_pu_lv  "SPEED10 1P8V, PU=40kOhm"
io8p10_arwsudq_ft_v33_lv  "SPEED10 1P8V"
io8p11_arwsudq_ft_v33_pd_lv  "SPEED11 1P8V, PD=40kOhm"
io8p11_arwsudq_ft_v33_pu_lv  "SPEED11 1P8V, PU=40kOhm"
io8p11_arwsudq_ft_v33_lv  "SPEED11 1P8V"
io8p00_arwsudq_ft_v33_pd  "SPEED00, PD=40kOhm"
io8p00_arwsudq_ft_v33_pu  "SPEED00, PU=40kOhm"
io8p00_arwsudq_ft_v33  "SPEED00"
io8p01_arwsudq_ft_v33_pd  "SPEED01, PD=40kOhm"
io8p01_arwsudq_ft_v33_pu  "SPEED01, PU=40kOhm"
io8p01_arwsudq_ft_v33  "SPEED01"
io8p10_arwsudq_ft_v33_pd  "SPEED10, PD=40kOhm"
io8p10_arwsudq_ft_v33_pu  "SPEED10, PU=40kOhm"
io8p10_arwsudq_ft_v33  "SPEED10"
io8p11_arwsudq_ft_v33_pd  "SPEED11, PD=40kOhm"
io8p11_arwsudq_ft_v33_pu  "SPEED11, PU=40kOhm"
io8p11_arwsudq_ft_v33  "SPEED11"
[Model Selector] io8usb_id_otg_ft
io8p00_id_otg_ft_pd_lv  "SPEED00 1P8V, PD=14kOhm"
io8p00_id_otg_ft_pu_lv  "SPEED00 1P8V, PU=14kOhm"
io8p00_id_otg_ft_lv  "SPEED00 1P8V"
io8p01_id_otg_ft_pd_lv  "SPEED01 1P8V, PD=14kOhm"
io8p01_id_otg_ft_pu_lv  "SPEED01 1P8V, PU=14kOhm"
io8p01_id_otg_ft_lv  "SPEED01 1P8V"
io8p10_id_otg_ft_pd_lv  "SPEED10 1P8V, PD=14kOhm"
io8p10_id_otg_ft_pu_lv  "SPEED10 1P8V, PU=14kOhm"
io8p10_id_otg_ft_lv  "SPEED10 1P8V"
io8p11_id_otg_ft_pd_lv  "SPEED11 1P8V, PD=14kOhm"
io8p11_id_otg_ft_pu_lv  "SPEED11 1P8V, PU=14kOhm"
io8p11_id_otg_ft_lv  "SPEED11 1P8V"
io8p00_id_otg_ft_pd  "SPEED00, PD=14kOhm"
io8p00_id_otg_ft_pu  "SPEED00, PU=14kOhm"
io8p00_id_otg_ft  "SPEED00"
io8p01_id_otg_ft_pd  "SPEED01, PD=14kOhm"
io8p01_id_otg_ft_pu  "SPEED01, PU=14kOhm"
io8p01_id_otg_ft  "SPEED01"
io8p10_id_otg_ft_pd  "SPEED10, PD=14kOhm"
io8p10_id_otg_ft_pu  "SPEED10, PU=14kOhm"
io8p10_id_otg_ft  "SPEED10"
io8p11_id_otg_ft_pd  "SPEED11, PD=14kOhm"
io8p11_id_otg_ft_pu  "SPEED11, PU=14kOhm"
io8p11_id_otg_ft  "SPEED11"
[Model Selector] io8usb_lsfs_otg_ft
io8usb_ls_otg_ft_dpdn_pd  "LS USB DP/DN IO + PD=20kOhm"
io8usb_ls_otg_ft_dpdn_pupu2  "LS USB DP/DN IO + PU/PU2=2.2kOhm"
io8usb_ls_otg_ft_dpdn_pu2  "LS USB DP/DN IO + PU2=1.2kOhm"
io8usb_ls_otg_ft_dpdn_pu  "LS USB DP/DN IO + PU=1.2kOhm"
io8usb_ls_otg_ft_dpdn  "LS USB DP/DN IO"
io8usb_fs_otg_ft_dpdn_pd  "HS USB DP/DN IO + PD=20kOhm"
io8usb_fs_otg_ft_dpdn_pupu2  "HS USB DP/DN IO + PU/PU2=2.2kOhm"
io8usb_fs_otg_ft_dpdn_pu2  "HS USB DP/DN IO + PU2=1.2kOhm"
io8usb_fs_otg_ft_dpdn_pu  "HS USB DP/DN IO + PU=1.2kOhm"
io8usb_fs_otg_ft_dpdn  "HS USB DP/DN IO"
io8p00_lsfs_otg_ft_pd_lv  "SPEED00 1P8V, PD=40kOhm"
io8p00_lsfs_otg_ft_pu_lv  "SPEED00 1P8V, PU=40kOhm"
io8p00_lsfs_otg_ft_lv  "SPEED00 1P8V"
io8p01_lsfs_otg_ft_pd_lv  "SPEED01 1P8V, PD=40kOhm"
io8p01_lsfs_otg_ft_pu_lv  "SPEED01 1P8V, PU=40kOhm"
io8p01_lsfs_otg_ft_lv  "SPEED01 1P8V"
io8p10_lsfs_otg_ft_pd_lv  "SPEED10 1P8V, PD=40kOhm"
io8p10_lsfs_otg_ft_pu_lv  "SPEED10 1P8V, PU=40kOhm"
io8p10_lsfs_otg_ft_lv  "SPEED10 1P8V"
io8p11_lsfs_otg_ft_pd_lv  "SPEED11 1P8V, PD=40kOhm"
io8p11_lsfs_otg_ft_pu_lv  "SPEED11 1P8V, PU=40kOhm"
io8p11_lsfs_otg_ft_lv  "SPEED11 1P8V"
io8p00_lsfs_otg_ft_pd  "SPEED00, PD=40kOhm"
io8p00_lsfs_otg_ft_pu  "SPEED00, PU=40kOhm"
io8p00_lsfs_otg_ft  "SPEED00"
io8p01_lsfs_otg_ft_pd  "SPEED01, PD=40kOhm"
io8p01_lsfs_otg_ft_pu  "SPEED01, PU=40kOhm"
io8p01_lsfs_otg_ft  "SPEED01"
io8p10_lsfs_otg_ft_pd  "SPEED10, PD=40kOhm"
io8p10_lsfs_otg_ft_pu  "SPEED10, PU=40kOhm"
io8p10_lsfs_otg_ft  "SPEED10"
io8p11_lsfs_otg_ft_pd  "SPEED11, PD=40kOhm"
io8p11_lsfs_otg_ft_pu  "SPEED11, PU=40kOhm"
io8p11_lsfs_otg_ft  "SPEED11"
[Model Selector] io8usb_vbus_otg_ft
io8psenb_vbus_otg_ft  "VBUS PULSE, SENSE VB"
io8psenab_vbus_otg_ft  "VBUS PULSE, SENSE VA and VB"
io8psena_vbus_otg_ft  "VBUS PULSE, SENSE VA"
io8psen_vbus_otg_ft  "VBUS PULSE"
io8p00_vbus_otg_ft_pd_lv  "SPEED00 1P8V, PD=40kOhm"
io8p00_vbus_otg_ft_pu_lv  "SPEED00 1P8V, PU=40kOhm"
io8p00_vbus_otg_ft_lv  "SPEED00 1P8V"
io8p01_vbus_otg_ft_pd_lv  "SPEED01 1P8V, PD=40kOhm"
io8p01_vbus_otg_ft_pu_lv  "SPEED01 1P8V, PU=40kOhm"
io8p01_vbus_otg_ft_lv  "SPEED01 1P8V"
io8p10_vbus_otg_ft_pd_lv  "SPEED10 1P8V, PD=40kOhm"
io8p10_vbus_otg_ft_pu_lv  "SPEED10 1P8V, PU=40kOhm"
io8p10_vbus_otg_ft_lv  "SPEED10 1P8V"
io8p11_vbus_otg_ft_pd_lv  "SPEED11 1P8V, PD=40kOhm"
io8p11_vbus_otg_ft_pu_lv  "SPEED11 1P8V, PU=40kOhm"
io8p11_vbus_otg_ft_lv  "SPEED11 1P8V"
io8p00_vbus_otg_ft_pd  "SPEED00, PD=40kOhm"
io8p00_vbus_otg_ft_pu  "SPEED00, PU=40kOhm"
io8p00_vbus_otg_ft  "SPEED00"
io8p01_vbus_otg_ft_pd  "SPEED01, PD=40kOhm"
io8p01_vbus_otg_ft_pu  "SPEED01, PU=40kOhm"
io8p01_vbus_otg_ft  "SPEED01"
io8p10_vbus_otg_ft_pd  "SPEED10, PD=40kOhm"
io8p10_vbus_otg_ft_pu  "SPEED10, PU=40kOhm"
io8p10_vbus_otg_ft  "SPEED10"
io8p11_vbus_otg_ft_pd  "SPEED11, PD=40kOhm"
io8p11_vbus_otg_ft_pu  "SPEED11, PU=40kOhm"
io8p11_vbus_otg_ft  "SPEED11"
[Model Selector] ioreset_ft_v33
ioreset_ft_v33_pu_lv  "ioreset 1P8V + PU=40kOhm"
ioreset_ft_v33_nopu_lv  "ioreset 1P8V"
ioreset_ft_v33_pu  "ioreset + PU=40kOhm"
ioreset_ft_v33_nopu  "ioreset"
[Model Selector] vpp_test_hv
vpp_test_hv_2p4  "Input Buffer 1P8V"
vpp_test_hv_3p3  "Input Buffer"
| Models and submodels in the file (260): io8p00_ar3wsudq_ft_pd_lv (I/O), io8p00_ar3wsudq_ft_pu_lv (I/O), io8p00_ar3wsudq_ft_lv (I/O), io8p01_ar3wsudq_ft_pd_lv (I/O), io8p01_ar3wsudq_ft_pu_lv (I/O), io8p01_ar3wsudq_ft_lv (I/O), io8p10_ar3wsudq_ft_pd_lv (I/O), io8p10_ar3wsudq_ft_pu_lv (I/O), io8p10_ar3wsudq_ft_lv (I/O), io8p11_ar3wsudq_ft_pd_lv (I/O), io8p11_ar3wsudq_ft_pu_lv (I/O), io8p11_ar3wsudq_ft_lv (I/O), io8p00_ar3wsudq_ft_pd (I/O), io8p00_ar3wsudq_ft_pu (I/O), io8p00_ar3wsudq_ft (I/O), io8p01_ar3wsudq_ft_pd (I/O), io8p01_ar3wsudq_ft_pu (I/O), io8p01_ar3wsudq_ft (I/O), io8p10_ar3wsudq_ft_pd (I/O), io8p10_ar3wsudq_ft_pu (I/O), io8p10_ar3wsudq_ft (I/O), io8p11_ar3wsudq_ft_pd (I/O), io8p11_ar3wsudq_ft_pu (I/O), io8p11_ar3wsudq_ft (I/O), io8p00_ar3wsudq_ft_v33_pd_lv (I/O), io8p00_ar3wsudq_ft_v33_pu_lv (I/O), io8p00_ar3wsudq_ft_v33_lv (I/O), io8p01_ar3wsudq_ft_v33_pd_lv (I/O), io8p01_ar3wsudq_ft_v33_pu_lv (I/O), io8p01_ar3wsudq_ft_v33_lv (I/O), io8p10_ar3wsudq_ft_v33_pd_lv (I/O), io8p10_ar3wsudq_ft_v33_pu_lv (I/O), io8p10_ar3wsudq_ft_v33_lv (I/O), io8p11_ar3wsudq_ft_v33_pd_lv (I/O), io8p11_ar3wsudq_ft_v33_pu_lv (I/O), io8p11_ar3wsudq_ft_v33_lv (I/O), io8p00_ar3wsudq_ft_v33_pd (I/O), io8p00_ar3wsudq_ft_v33_pu (I/O), io8p00_ar3wsudq_ft_v33 (I/O), io8p01_ar3wsudq_ft_v33_pd (I/O), io8p01_ar3wsudq_ft_v33_pu (I/O), io8p01_ar3wsudq_ft_v33 (I/O), io8p10_ar3wsudq_ft_v33_pd (I/O), io8p10_ar3wsudq_ft_v33_pu (I/O), io8p10_ar3wsudq_ft_v33 (I/O), io8p11_ar3wsudq_ft_v33_pd (I/O), io8p11_ar3wsudq_ft_v33_pu (I/O), io8p11_ar3wsudq_ft_v33 (I/O), io8p00_arsudq_ft_pd_lv (I/O), io8p00_arsudq_ft_pu_lv (I/O), io8p00_arsudq_ft_lv (I/O), io8p01_arsudq_ft_pd_lv (I/O), io8p01_arsudq_ft_pu_lv (I/O), io8p01_arsudq_ft_lv (I/O), io8p10_arsudq_ft_pd_lv (I/O), io8p10_arsudq_ft_pu_lv (I/O), io8p10_arsudq_ft_lv (I/O), io8p11_arsudq_ft_pd_lv (I/O), io8p11_arsudq_ft_pu_lv (I/O), io8p11_arsudq_ft_lv (I/O), io8p00_arsudq_ft_pd (I/O), io8p00_arsudq_ft_pu (I/O), io8p00_arsudq_ft (I/O), io8p01_arsudq_ft_pd (I/O), io8p01_arsudq_ft_pu (I/O), io8p01_arsudq_ft (I/O), io8p10_arsudq_ft_pd (I/O), io8p10_arsudq_ft_pu (I/O), io8p10_arsudq_ft (I/O), io8p11_arsudq_ft_pd (I/O), io8p11_arsudq_ft_pu (I/O), io8p11_arsudq_ft (I/O), io8p00_arsudq_ft_v33_pd_lv (I/O), io8p00_arsudq_ft_v33_pu_lv (I/O), io8p00_arsudq_ft_v33_lv (I/O), io8p01_arsudq_ft_v33_pd_lv (I/O), io8p01_arsudq_ft_v33_pu_lv (I/O), io8p01_arsudq_ft_v33_lv (I/O), io8p10_arsudq_ft_v33_pd_lv (I/O), io8p10_arsudq_ft_v33_pu_lv (I/O)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
