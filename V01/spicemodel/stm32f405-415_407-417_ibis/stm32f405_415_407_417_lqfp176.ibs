|   stm32f405_415_407_417_lqfp176 IBIS Model
[IBIS ver]   4.2
[File name]  stm32f405_415_407_417_lqfp176.ibs
[File Rev]   1.3
[Date]   05-30-2014
[Source] Data Created at STMicroelectronics
[Notes]   File originated from ELDO simulations.
[Disclaimer]  This information is for modeling purpose only and is
   not guaranted. The information is subject to change without
   notice.
[Copyright] Copyright 2014 STMicroelectronics Inc.
[Component] stm32f405_415_407_417_lqfp176
[Manufacturer] STMicroelectronics
[Package]
| variable   typ   min   max
R_pkg   0.0   NA   NA
L_pkg   0.0H   NA   NA
C_pkg   0.0F   NA   NA
[Pin]   signal_name   model_name   R_pin   L_pin   C_pin
1   PE2   io8p_arsudq_ft   235.0E-3   11.5E-9   327.0E-15
2   PE3   io8p_arsudq_ft   229.9E-3   11.2E-9   303.3E-15
3   PE4   io8p_arsudq_ft   225.0E-3   10.8E-9   280.8E-15
4   PE5   io8p_arsudq_ft   220.4E-3   10.5E-9   259.5E-15
5   PE6   io8p_arsudq_ft   216.0E-3   10.3E-9   239.3E-15
6   VBAT   POWER   211.9E-3   10.0E-9   220.2E-15
7   PI8   io8p_arsudq_ft_v33   208.1E-3   9.7E-9   202.3E-15
8   PC13   io8p_arwsudq_ft_v33   204.4E-3   9.5E-9   185.6E-15
9   PC14   io8p_arwsudq_ft   201.1E-3   9.3E-9   170.0E-15
10   PC15   io8p_arsudq_ft   198.0E-3   9.1E-9   155.6E-15
11   PI9   io8p_arsudq_ft   195.1E-3   8.9E-9   142.3E-15
12   PI10   io8p_arsudq_ft   192.5E-3   8.7E-9   130.2E-15
13   PI11   io8p_arsudq_ft   190.1E-3   8.6E-9   119.2E-15
14   VSS   GND   188.0E-3   8.4E-9   109.4E-15
15   VDD   POWER   186.1E-3   8.3E-9   100.8E-15
16   PF0   io8p_arsudq_i2cin_ft   184.5E-3   8.2E-9   93.3E-15
17   PF1   io8p_arsudq_i2cin_ft   183.1E-3   8.1E-9   86.9E-15
18   PF2   io8p_arsudq_ft   182.0E-3   8.0E-9   81.7E-15
19   PF3   io8p_arwsudq_ft   181.1E-3   8.0E-9   77.7E-15
20   PF4   io8p_arwsudq_ft   180.5E-3   7.9E-9   74.8E-15
21   PF5   io8p_arwsudq_ft   180.1E-3   7.9E-9   73.1E-15
22   VSS   GND   180.0E-3   7.9E-9   72.5E-15
23   VDD   POWER   180.0E-3   7.9E-9   72.5E-15
24   PF6   io8p_arwsudq_ft   180.1E-3   7.9E-9   73.1E-15
25   PF7   io8p_arwsudq_ft   180.5E-3   7.9E-9   74.8E-15
26   PF8   io8p_arwsudq_ft   181.1E-3   8.0E-9   77.7E-15
27   PF9   io8p_arwsudq_ft   182.0E-3   8.0E-9   81.7E-15
28   PF10   io8p_arwsudq_ft   183.1E-3   8.1E-9   86.9E-15
29   PH0   io8p_arsudq_ft   184.5E-3   8.2E-9   93.3E-15
30   PH1   io8p_arsudq_ft   186.1E-3   8.3E-9   100.8E-15
31   NRST   ioreset_ft_v33   188.0E-3   8.4E-9   109.4E-15
32   PC0   io8p_ar3wsudq_ft   190.1E-3   8.6E-9   119.2E-15
33   PC1   io8p_ar3wsudq_ft   192.5E-3   8.7E-9   130.2E-15
34   PC2   io8p_ar3wsudq_ft   195.1E-3   8.9E-9   142.3E-15
35   PC3   io8p_ar3wsudq_ft   198.0E-3   9.1E-9   155.6E-15
36   VDD   POWER   201.1E-3   9.3E-9   170.0E-15
37   VREFM   POWER   204.4E-3   9.5E-9   185.6E-15
38   VREFP   POWER   208.1E-3   9.7E-9   202.3E-15
39   VDDA   POWER   211.9E-3   10.0E-9   220.2E-15
40   PA0   io8p_ar3wsudq_ft_v33   216.0E-3   10.3E-9   239.3E-15
41   PA1   io8p_ar3wsudq_ft   220.4E-3   10.5E-9   259.5E-15
42   PA2   io8p_ar3wsudq_ft   225.0E-3   10.8E-9   280.8E-15
43   PH2   io8p_arsudq_ft   229.9E-3   11.2E-9   303.3E-15
44   PH3   io8p_arsudq_ft   235.0E-3   11.5E-9   327.0E-15
45   PH4   io8p_arsudq_i2cin_ft   235.0E-3   11.5E-9   327.0E-15
46   PH5   io8p_arsudq_i2cin_ft   229.9E-3   11.2E-9   303.3E-15
47   PA3   io8p_ar3wsudq_ft   225.0E-3   10.8E-9   280.8E-15
48   BYPPASS_REG   io8p_arsudq_ft_v33   220.4E-3   10.5E-9   259.5E-15
49   VDD   POWER   216.0E-3   10.3E-9   239.3E-15
50   PA4   io8p_ar3wsudq_ft   211.9E-3   10.0E-9   220.2E-15
51   PA5   io8p_ar3wsudq_ft   208.1E-3   9.7E-9   202.3E-15
52   PA6   io8p_ar3wsudq_ft   204.4E-3   9.5E-9   185.6E-15
53   PA7   io8p_ar3wsudq_ft   201.1E-3   9.3E-9   170.0E-15
54   PC4   io8p_ar3wsudq_ft   198.0E-3   9.1E-9   155.6E-15
55   PC5   io8p_ar3wsudq_ft   195.1E-3   8.9E-9   142.3E-15
56   PB0   io8p_ar3wsudq_ft   192.5E-3   8.7E-9   130.2E-15
57   PB1   io8p_ar3wsudq_ft   190.1E-3   8.6E-9   119.2E-15
58   PB2   io8p_ar3wsudq_ft   188.0E-3   8.4E-9   109.4E-15
59   PF11   io8p_arsudq_ft   186.1E-3   8.3E-9   100.8E-15
60   PF12   io8p_arsudq_ft   184.5E-3   8.2E-9   93.3E-15
61   VSS   GND   183.1E-3   8.1E-9   86.9E-15
62   VDD   POWER   182.0E-3   8.0E-9   81.7E-15
63   PF13   io8p_arsudq_ft   181.1E-3   8.0E-9   77.7E-15
64   PF14   io8p_arsudq_ft   180.5E-3   7.9E-9   74.8E-15
65   PF15   io8p_arsudq_ft   180.1E-3   7.9E-9   73.1E-15
66   PG0   io8p_arsudq_ft   180.0E-3   7.9E-9   72.5E-15
67   PG1   io8p_arsudq_ft   180.0E-3   7.9E-9   72.5E-15
68   PE7   io8p_arsudq_ft   180.1E-3   7.9E-9   73.1E-15
69   PE8   io8p_arsudq_ft   180.5E-3   7.9E-9   74.8E-15
70   PE9   io8p_arsudq_ft   181.1E-3   8.0E-9   77.7E-15
71   VSS   GND   182.0E-3   8.0E-9   81.7E-15
72   VDD   POWER   183.1E-3   8.1E-9   86.9E-15
73   PE10   io8p_arsudq_ft   184.5E-3   8.2E-9   93.3E-15
74   PE11   io8p_arsudq_ft   186.1E-3   8.3E-9   100.8E-15
75   PE12   io8p_arsudq_ft   188.0E-3   8.4E-9   109.4E-15
76   PE13   io8p_arsudq_ft   190.1E-3   8.6E-9   119.2E-15
77   PE14   io8p_arsudq_ft   192.5E-3   8.7E-9   130.2E-15
78   PE15   io8p_ar3wsudq_ft   195.1E-3   8.9E-9   142.3E-15
79   PB10   io8p_arsudq_i2cin_ft   198.0E-3   9.1E-9   155.6E-15
80   PB11   io8p_arsudq_i2cin_ft   201.1E-3   9.3E-9   170.0E-15
81   VCAP1   POWER   204.4E-3   9.5E-9   185.6E-15
82   VDD   POWER   208.1E-3   9.7E-9   202.3E-15
83   PH6   io8p_arsudq_ft   211.9E-3   10.0E-9   220.2E-15
84   PH7   io8p_arsudq_i2cin_ft   216.0E-3   10.3E-9   239.3E-15
85   PH8   io8p_arsudq_i2cin_ft   220.4E-3   10.5E-9   259.5E-15
86   PH9   io8p_arsudq_ft   225.0E-3   10.8E-9   280.8E-15
87   PH10   io8p_arsudq_ft   229.9E-3   11.2E-9   303.3E-15
88   PH11   io8p_arsudq_ft   235.0E-3   11.5E-9   327.0E-15
89   PH12   io8p_arsudq_ft   235.0E-3   11.5E-9   327.0E-15
90   VSS   GND   229.9E-3   11.2E-9   303.3E-15
91   VDD   POWER   225.0E-3   10.8E-9   280.8E-15
92   PB12   io8usb_id_otg_ft   220.4E-3   10.5E-9   259.5E-15
93   PB13   io8usb_vbus_otg_ft   216.0E-3   10.3E-9   239.3E-15
94   PB14   io8usb_lsfs_otg_ft   211.9E-3   10.0E-9   220.2E-15
95   PB15   io8usb_lsfs_otg_ft   208.1E-3   9.7E-9   202.3E-15
96   PD8   io8p_arsudq_ft   204.4E-3   9.5E-9   185.6E-15
97   PD9   io8p_arsudq_ft   201.1E-3   9.3E-9   170.0E-15
98   PD10   io8p_arsudq_ft   198.0E-3   9.1E-9   155.6E-15
99   PD11   io8p_arsudq_ft   195.1E-3   8.9E-9   142.3E-15
100   PD12   io8p_arsudq_ft   192.5E-3   8.7E-9   130.2E-15
101   PD13   io8p_arsudq_ft   190.1E-3   8.6E-9   119.2E-15
102   VSS   GND   188.0E-3   8.4E-9   109.4E-15
103   VDD   POWER   186.1E-3   8.3E-9   100.8E-15
104   PD14   io8p_arsudq_ft   184.5E-3   8.2E-9   93.3E-15
105   PD15   io8p_arsudq_ft   183.1E-3   8.1E-9   86.9E-15
106   PG2   io8p_arsudq_ft   182.0E-3   8.0E-9   81.7E-15
107   PG3   io8p_arsudq_ft   181.1E-3   8.0E-9   77.7E-15
108   PG4   io8p_arsudq_ft   180.5E-3   7.9E-9   74.8E-15
109   PG5   io8p_arsudq_ft   180.1E-3   7.9E-9   73.1E-15
110   PG6   io8p_arsudq_ft   180.0E-3   7.9E-9   72.5E-15
111   PG7   io8p_arsudq_ft   180.0E-3   7.9E-9   72.5E-15
112   PG8   io8p_arsudq_ft   180.1E-3   7.9E-9   73.1E-15
113   VSS   GND   180.5E-3   7.9E-9   74.8E-15
114   VDD   POWER   181.1E-3   8.0E-9   77.7E-15
115   PC6   io8p_arsudq_ft   182.0E-3   8.0E-9   81.7E-15
116   PC7   io8p_arsudq_ft   183.1E-3   8.1E-9   86.9E-15
117   PC8   io8p_arsudq_ft   184.5E-3   8.2E-9   93.3E-15
118   PC9   io8p_arsudq_i2cin_ft   186.1E-3   8.3E-9   100.8E-15
119   PA8   io8p_arsudq_i2cin_ft   188.0E-3   8.4E-9   109.4E-15
120   PA9   io8usb_vbus_otg_ft   190.1E-3   8.6E-9   119.2E-15
121   PA10   io8usb_id_otg_ft   192.5E-3   8.7E-9   130.2E-15
122   PA11   io8usb_lsfs_otg_ft   195.1E-3   8.9E-9   142.3E-15
123   PA12   io8usb_lsfs_otg_ft   198.0E-3   9.1E-9   155.6E-15
124   PA13   io8p_arsudq_ft   201.1E-3   9.3E-9   170.0E-15
125   VCAP2   POWER   204.4E-3   9.5E-9   185.6E-15
126   VSS   GND   208.1E-3   9.7E-9   202.3E-15
127   VDD   POWER   211.9E-3   10.0E-9   220.2E-15
128   PH13   io8p_arsudq_ft   216.0E-3   10.3E-9   239.3E-15
129   PH14   io8p_arsudq_ft   220.4E-3   10.5E-9   259.5E-15
130   PH15   io8p_arsudq_ft   225.0E-3   10.8E-9   280.8E-15
131   PI0   io8p_arsudq_ft   229.9E-3   11.2E-9   303.3E-15
132   PI1   io8p_arsudq_ft   235.0E-3   11.5E-9   327.0E-15
133   PI2   io8p_arsudq_ft   235.0E-3   11.5E-9   327.0E-15
134   PI3   io8p_arsudq_ft   229.9E-3   11.2E-9   303.3E-15
135   VSS   GND   225.0E-3   10.8E-9   280.8E-15
136   VDD   POWER   220.4E-3   10.5E-9   259.5E-15
137   PA14   io8p_arsudq_ft   216.0E-3   10.3E-9   239.3E-15
138   PA15   io8p_arsudq_ft   211.9E-3   10.0E-9   220.2E-15
139   PC10   io8p_arsudq_ft   208.1E-3   9.7E-9   202.3E-15
140   PC11   io8p_arsudq_ft   204.4E-3   9.5E-9   185.6E-15
141   PC12   io8p_arsudq_ft   201.1E-3   9.3E-9   170.0E-15
142   PD0   io8p_arsudq_ft   198.0E-3   9.1E-9   155.6E-15
143   PD1   io8p_arsudq_ft   195.1E-3   8.9E-9   142.3E-15
144   PD2   io8p_arsudq_ft   192.5E-3   8.7E-9   130.2E-15
145   PD3   io8p_arsudq_ft   190.1E-3   8.6E-9   119.2E-15
146   PD4   io8p_arsudq_ft   188.0E-3   8.4E-9   109.4E-15
147   PD5   io8p_arsudq_ft   186.1E-3   8.3E-9   100.8E-15
148   VSS   GND   184.5E-3   8.2E-9   93.3E-15
149   VDD   POWER   183.1E-3   8.1E-9   86.9E-15
150   PD6   io8p_arsudq_ft   182.0E-3   8.0E-9   81.7E-15
151   PD7   io8p_arsudq_ft   181.1E-3   8.0E-9   77.7E-15
152   PG9   io8p_arsudq_ft   180.5E-3   7.9E-9   74.8E-15
153   PG10   io8p_arsudq_ft   180.1E-3   7.9E-9   73.1E-15
154   PG11   io8p_arsudq_ft   180.0E-3   7.9E-9   72.5E-15
155   PG12   io8p_arsudq_ft   180.0E-3   7.9E-9   72.5E-15
156   PG13   io8p_arsudq_ft   180.1E-3   7.9E-9   73.1E-15
157   PG14   io8p_arsudq_ft   180.5E-3   7.9E-9   74.8E-15
158   VSS   GND   181.1E-3   8.0E-9   77.7E-15
159   VDD   POWER   182.0E-3   8.0E-9   81.7E-15
160   PG15   io8p_arsudq_ft   183.1E-3   8.1E-9   86.9E-15
161   PB3   io8p_arsudq_ft   184.5E-3   8.2E-9   93.3E-15
162   PB4   io8p_arsudq_ft   186.1E-3   8.3E-9   100.8E-15
163   PB5   io8p_ar3wsudq_ft   188.0E-3   8.4E-9   109.4E-15
164   PB6   io8p_arsudq_i2cin_ft   190.1E-3   8.6E-9   119.2E-15
165   PB7   io8p_arsudq_i2cin_ft   192.5E-3   8.7E-9   130.2E-15
166   BOOT0   vpp_test_hv   195.1E-3   8.9E-9   142.3E-15
167   PB8   io8p_arsudq_i2cin_ft   198.0E-3   9.1E-9   155.6E-15
168   PB9   io8p_arsudq_i2cin_ft   201.1E-3   9.3E-9   170.0E-15
169   PE0   io8p_arsudq_ft   204.4E-3   9.5E-9   185.6E-15
170   PE1   io8p_arsudq_ft   208.1E-3   9.7E-9   202.3E-15
171   PDR_ON   io8p_arsudq_ft_v33   211.9E-3   10.0E-9   220.2E-15
172   VDD   POWER   216.0E-3   10.3E-9   239.3E-15
173   PI4   io8p_arsudq_ft   220.4E-3   10.5E-9   259.5E-15
174   PI5   io8p_arsudq_ft   225.0E-3   10.8E-9   280.8E-15
175   PI6   io8p_arsudq_ft   229.9E-3   11.2E-9   303.3E-15
176   PI7   io8p_arsudq_ft   235.0E-3   11.5E-9   327.0E-15
[Diff Pin]   inv_pin   vdiff   tdelay_typ  tdelay_min  tdelay_max
95   94   200mV   NA   NA   NA
123   122   200mV   NA   NA   NA
[Model Selector] io8p_ar3wsudq_ft
io8p00_ar3wsudq_ft_pd_lv  "SPEED00 1P8V, PD=40kOhm"
io8p00_ar3wsudq_ft_pu_lv  "SPEED00 1P8V, PU=40kOhm"
io8p00_ar3wsudq_ft_lv  "SPEED00 1P8V"
io8p01_ar3wsudq_ft_pd_lv  "SPEED01 1P8V, PD=40kOhm"
io8p01_ar3wsudq_ft_pu_lv  "SPEED01 1P8V, PU=40kOhm"
io8p01_ar3wsudq_ft_lv  "SPEED01 1P8V"
io8p10_ar3wsudq_ft_pd_lv  "SPEED10 1P8V, PD=40kOhm"
io8p10_ar3wsudq_ft_pu_lv  "SPEED10 1P8V, PU=40kOhm"
io8p10_ar3wsudq_ft_lv  "SPEED10 1P8V"
io8p11_ar3wsudq_ft_pd_lv  "SPEED11 1P8V, PD=40kOhm"
io8p11_ar3wsudq_ft_pu_lv  "SPEED11 1P8V, PU=40kOhm"
io8p11_ar3wsudq_ft_lv  "SPEED11 1P8V"
io8p00_ar3wsudq_ft_pd  "SPEED00, PD=40kOhm"
io8p00_ar3wsudq_ft_pu  "SPEED00, PU=40kOhm"
io8p00_ar3wsudq_ft  "SPEED00"
io8p01_ar3wsudq_ft_pd  "SPEED01, PD=40kOhm"
io8p01_ar3wsudq_ft_pu  "SPEED01, PU=40kOhm"
io8p01_ar3wsudq_ft  "SPEED01"
io8p10_ar3wsudq_ft_pd  "SPEED10, PD=40kOhm"
io8p10_ar3wsudq_ft_pu  "SPEED10, PU=40kOhm"
io8p10_ar3wsudq_ft  "SPEED10"
io8p11_ar3wsudq_ft_pd  "SPEED11, PD=40kOhm"
io8p11_ar3wsudq_ft_pu  "SPEED11, PU=40kOhm"
io8p11_ar3wsudq_ft  "SPEED11"
[Model Selector] io8p_ar3wsudq_ft_v33
io8p00_ar3wsudq_ft_v33_pd_lv  "SPEED00 1P8V, PD=40kOhm"
io8p00_ar3wsudq_ft_v33_pu_lv  "SPEED00 1P8V, PU=40kOhm"
io8p00_ar3wsudq_ft_v33_lv  "SPEED00 1P8V"
io8p01_ar3wsudq_ft_v33_pd_lv  "SPEED01 1P8V, PD=40kOhm"
io8p01_ar3wsudq_ft_v33_pu_lv  "SPEED01 1P8V, PU=40kOhm"
io8p01_ar3wsudq_ft_v33_lv  "SPEED01 1P8V"
io8p10_ar3wsudq_ft_v33_pd_lv  "SPEED10 1P8V, PD=40kOhm"
io8p10_ar3wsudq_ft_v33_pu_lv  "SPEED10 1P8V, PU=40kOhm"
io8p10_ar3wsudq_ft_v33_lv  "SPEED10 1P8V"
io8p11_ar3wsudq_ft_v33_pd_lv  "SPEED11 1P8V, PD=40kOhm"
io8p11_ar3wsudq_ft_v33_pu_lv  "SPEED11 1P8V, PU=40kOhm"
io8p11_ar3wsudq_ft_v33_lv  "SPEED11 1P8V"
io8p00_ar3wsudq_ft_v33_pd  "SPEED00, PD=40kOhm"
io8p00_ar3wsudq_ft_v33_pu  "SPEED00, PU=40kOhm"
io8p00_ar3wsudq_ft_v33  "SPEED00"
io8p01_ar3wsudq_ft_v33_pd  "SPEED01, PD=40kOhm"
io8p01_ar3wsudq_ft_v33_pu  "SPEED01, PU=40kOhm"
io8p01_ar3wsudq_ft_v33  "SPEED01"
io8p10_ar3wsudq_ft_v33_pd  "SPEED10, PD=40kOhm"
io8p10_ar3wsudq_ft_v33_pu  "SPEED10, PU=40kOhm"
io8p10_ar3wsudq_ft_v33  "SPEED10"
io8p11_ar3wsudq_ft_v33_pd  "SPEED11, PD=40kOhm"
io8p11_ar3wsudq_ft_v33_pu  "SPEED11, PU=40kOhm"
io8p11_ar3wsudq_ft_v33  "SPEED11"
[Model Selector] io8p_arsudq_ft
io8p00_arsudq_ft_pd_lv  "SPEED00 1P8V, PD=40kOhm"
io8p00_arsudq_ft_pu_lv  "SPEED00 1P8V, PU=40kOhm"
io8p00_arsudq_ft_lv  "SPEED00 1P8V"
io8p01_arsudq_ft_pd_lv  "SPEED01 1P8V, PD=40kOhm"
io8p01_arsudq_ft_pu_lv  "SPEED01 1P8V, PU=40kOhm"
io8p01_arsudq_ft_lv  "SPEED01 1P8V"
io8p10_arsudq_ft_pd_lv  "SPEED10 1P8V, PD=40kOhm"
io8p10_arsudq_ft_pu_lv  "SPEED10 1P8V, PU=40kOhm"
io8p10_arsudq_ft_lv  "SPEED10 1P8V"
io8p11_arsudq_ft_pd_lv  "SPEED11 1P8V, PD=40kOhm"
io8p11_arsudq_ft_pu_lv  "SPEED11 1P8V, PU=40kOhm"
io8p11_arsudq_ft_lv  "SPEED11 1P8V"
io8p00_arsudq_ft_pd  "SPEED00, PD=40kOhm"
io8p00_arsudq_ft_pu  "SPEED00, PU=40kOhm"
io8p00_arsudq_ft  "SPEED00"
io8p01_arsudq_ft_pd  "SPEED01, PD=40kOhm"
io8p01_arsudq_ft_pu  "SPEED01, PU=40kOhm"
io8p01_arsudq_ft  "SPEED01"
io8p10_arsudq_ft_pd  "SPEED10, PD=40kOhm"
io8p10_arsudq_ft_pu  "SPEED10, PU=40kOhm"
io8p10_arsudq_ft  "SPEED10"
io8p11_arsudq_ft_pd  "SPEED11, PD=40kOhm"
io8p11_arsudq_ft_pu  "SPEED11, PU=40kOhm"
io8p11_arsudq_ft  "SPEED11"
[Model Selector] io8p_arsudq_ft_v33
io8p00_arsudq_ft_v33_pd_lv  "SPEED00 1P8V, PD=40kOhm"
io8p00_arsudq_ft_v33_pu_lv  "SPEED00 1P8V, PU=40kOhm"
io8p00_arsudq_ft_v33_lv  "SPEED00 1P8V"
io8p01_arsudq_ft_v33_pd_lv  "SPEED01 1P8V, PD=40kOhm"
io8p01_arsudq_ft_v33_pu_lv  "SPEED01 1P8V, PU=40kOhm"
io8p01_arsudq_ft_v33_lv  "SPEED01 1P8V"
io8p10_arsudq_ft_v33_pd_lv  "SPEED10 1P8V, PD=40kOhm"
io8p10_arsudq_ft_v33_pu_lv  "SPEED10 1P8V, PU=40kOhm"
io8p10_arsudq_ft_v33_lv  "SPEED10 1P8V"
io8p11_arsudq_ft_v33_pd_lv  "SPEED11 1P8V, PD=40kOhm"
io8p11_arsudq_ft_v33_pu_lv  "SPEED11 1P8V, PU=40kOhm"
io8p11_arsudq_ft_v33_lv  "SPEED11 1P8V"
io8p00_arsudq_ft_v33_pd  "SPEED00, PD=40kOhm"
io8p00_arsudq_ft_v33_pu  "SPEED00, PU=40kOhm"
io8p00_arsudq_ft_v33  "SPEED00"
io8p01_arsudq_ft_v33_pd  "SPEED01, PD=40kOhm"
io8p01_arsudq_ft_v33_pu  "SPEED01, PU=40kOhm"
io8p01_arsudq_ft_v33  "SPEED01"
io8p10_arsudq_ft_v33_pd  "SPEED10, PD=40kOhm"
io8p10_arsudq_ft_v33_pu  "SPEED10, PU=40kOhm"
io8p10_arsudq_ft_v33  "SPEED10"
io8p11_arsudq_ft_v33_pd  "SPEED11, PD=40kOhm"
io8p11_arsudq_ft_v33_pu  "SPEED11, PU=40kOhm"
io8p11_arsudq_ft_v33  "SPEED11"
[Model Selector] io8p_arsudq_i2cin_ft
io8p00_arsudq_i2cin_ft_pd_lv  "SPEED00 1P8V, PD=40kOhm"
io8p00_arsudq_i2cin_ft_pu_lv  "SPEED00 1P8V, PU=40kOhm"
io8p00_arsudq_i2cin_ft_lv  "SPEED00 1P8V"
io8p01_arsudq_i2cin_ft_pd_lv  "SPEED01 1P8V, PD=40kOhm"
io8p01_arsudq_i2cin_ft_pu_lv  "SPEED01 1P8V, PU=40kOhm"
io8p01_arsudq_i2cin_ft_lv  "SPEED01 1P8V"
io8p10_arsudq_i2cin_ft_pd_lv  "SPEED10 1P8V, PD=40kOhm"
io8p10_arsudq_i2cin_ft_pu_lv  "SPEED10 1P8V, PU=40kOhm"
io8p10_arsudq_i2cin_ft_lv  "SPEED10 1P8V"
io8p11_arsudq_i2cin_ft_pd_lv  "SPEED11 1P8V, PD=40kOhm"
io8p11_arsudq_i2cin_ft_pu_lv  "SPEED11 1P8V, PU=40kOhm"
io8p11_arsudq_i2cin_ft_lv  "SPEED11 1P8V"
io8p00_arsudq_i2cin_ft_pd  "SPEED00, PD=40kOhm"
io8p00_arsudq_i2cin_ft_pu  "SPEED00, PU=40kOhm"
io8p00_arsudq_i2cin_ft  "SPEED00"
io8p01_arsudq_i2cin_ft_pd  "SPEED01, PD=40kOhm"
io8p01_arsudq_i2cin_ft_pu  "SPEED01, PU=40kOhm"
io8p01_arsudq_i2cin_ft  "SPEED01"
io8p10_arsudq_i2cin_ft_pd  "SPEED10, PD=40kOhm"
io8p10_arsudq_i2cin_ft_pu  "SPEED10, PU=40kOhm"
io8p10_arsudq_i2cin_ft  "SPEED10"
io8p11_arsudq_i2cin_ft_pd  "SPEED11, PD=40kOhm"
io8p11_arsudq_i2cin_ft_pu  "SPEED11, PU=40kOhm"
io8p11_arsudq_i2cin_ft  "SPEED11"
[Model Selector] io8p_arwsudq_ft
io8p00_arwsudq_ft_pd_lv  "SPEED00 1P8V, PD=40kOhm"
io8p00_arwsudq_ft_pu_lv  "SPEED00 1P8V, PU=40kOhm"
io8p00_arwsudq_ft_lv  "SPEED00 1P8V"
io8p01_arwsudq_ft_pd_lv  "SPEED01 1P8V, PD=40kOhm"
io8p01_arwsudq_ft_pu_lv  "SPEED01 1P8V, PU=40kOhm"
io8p01_arwsudq_ft_lv  "SPEED01 1P8V"
io8p10_arwsudq_ft_pd_lv  "SPEED10 1P8V, PD=40kOhm"
io8p10_arwsudq_ft_pu_lv  "SPEED10 1P8V, PU=40kOhm"
io8p10_arwsudq_ft_lv  "SPEED10 1P8V"
io8p11_arwsudq_ft_pd_lv  "SPEED11 1P8V, PD=40kOhm"
io8p11_arwsudq_ft_pu_lv  "SPEED11 1P8V, PU=40kOhm"
io8p11_arwsudq_ft_lv  "SPEED11 1P8V"
io8p00_arwsudq_ft_pd  "SPEED00, PD=40kOhm"
io8p00_arwsudq_ft_pu  "SPEED00, PU=40kOhm"
io8p00_arwsudq_ft  "SPEED00"
io8p01_arwsudq_ft_pd  "SPEED01, PD=40kOhm"
io8p01_arwsudq_ft_pu  "SPEED01, PU=40kOhm"
io8p01_arwsudq_ft  "SPEED01"
io8p10_arwsudq_ft_pd  "SPEED10, PD=40kOhm"
io8p10_arwsudq_ft_pu  "SPEED10, PU=40kOhm"
io8p10_arwsudq_ft  "SPEED10"
io8p11_arwsudq_ft_pd  "SPEED11, PD=40kOhm"
io8p11_arwsudq_ft_pu  "SPEED11, PU=40kOhm"
io8p11_arwsudq_ft  "SPEED11"
[Model Selector] io8p_arwsudq_ft_v33
io8p00_arwsudq_ft_v33_pd_lv  "SPEED00 1P8V, PD=40kOhm"
io8p00_arwsudq_ft_v33_pu_lv  "SPEED00 1P8V, PU=40kOhm"
io8p00_arwsudq_ft_v33_lv  "SPEED00 1P8V"
io8p01_arwsudq_ft_v33_pd_lv  "SPEED01 1P8V, PD=40kOhm"
io8p01_arwsudq_ft_v33_pu_lv  "SPEED01 1P8V, PU=40kOhm"
io8p01_arwsudq_ft_v33_lv  "SPEED01 1P8V"
io8p10_arwsudq_ft_v33_pd_lv  "SPEED10 1P8V, PD=40kOhm"
io8p10_arwsudq_ft_v33_pu_lv  "SPEED10 1P8V, PU=40kOhm"
io8p10_arwsudq_ft_v33_lv  "SPEED10 1P8V"
io8p11_arwsudq_ft_v33_pd_lv  "SPEED11 1P8V, PD=40kOhm"
io8p11_arwsudq_ft_v33_pu_lv  "SPEED11 1P8V, PU=40kOhm"
io8p11_arwsudq_ft_v33_lv  "SPEED11 1P8V"
io8p00_arwsudq_ft_v33_pd  "SPEED00, PD=40kOhm"
io8p00_arwsudq_ft_v33_pu  "SPEED00, PU=40kOhm"
io8p00_arwsudq_ft_v33  "SPEED00"
io8p01_arwsudq_ft_v33_pd  "SPEED01, PD=40kOhm"
io8p01_arwsudq_ft_v33_pu  "SPEED01, PU=40kOhm"
io8p01_arwsudq_ft_v33  "SPEED01"
io8p10_arwsudq_ft_v33_pd  "SPEED10, PD=40kOhm"
io8p10_arwsudq_ft_v33_pu  "SPEED10, PU=40kOhm"
io8p10_arwsudq_ft_v33  "SPEED10"
io8p11_arwsudq_ft_v33_pd  "SPEED11, PD=40kOhm"
io8p11_arwsudq_ft_v33_pu  "SPEED11, PU=40kOhm"
io8p11_arwsudq_ft_v33  "SPEED11"
[Model Selector] io8usb_id_otg_ft
io8p00_id_otg_ft_pd_lv  "SPEED00 1P8V, PD=14kOhm"
io8p00_id_otg_ft_pu_lv  "SPEED00 1P8V, PU=14kOhm"
io8p00_id_otg_ft_lv  "SPEED00 1P8V"
io8p01_id_otg_ft_pd_lv  "SPEED01 1P8V, PD=14kOhm"
io8p01_id_otg_ft_pu_lv  "SPEED01 1P8V, PU=14kOhm"
io8p01_id_otg_ft_lv  "SPEED01 1P8V"
io8p10_id_otg_ft_pd_lv  "SPEED10 1P8V, PD=14kOhm"
io8p10_id_otg_ft_pu_lv  "SPEED10 1P8V, PU=14kOhm"
io8p10_id_otg_ft_lv  "SPEED10 1P8V"
io8p11_id_otg_ft_pd_lv  "SPEED11 1P8V, PD=14kOhm"
io8p11_id_otg_ft_pu_lv  "SPEED11 1P8V, PU=14kOhm"
io8p11_id_otg_ft_lv  "SPEED11 1P8V"
io8p00_id_otg_ft_pd  "SPEED00, PD=14kOhm"
io8p00_id_otg_ft_pu  "SPEED00, PU=14kOhm"
io8p00_id_otg_ft  "SPEED00"
io8p01_id_otg_ft_pd  "SPEED01, PD=14kOhm"
io8p01_id_otg_ft_pu  "SPEED01, PU=14kOhm"
io8p01_id_otg_ft  "SPEED01"
io8p10_id_otg_ft_pd  "SPEED10, PD=14kOhm"
io8p10_id_otg_ft_pu  "SPEED10, PU=14kOhm"
io8p10_id_otg_ft  "SPEED10"
io8p11_id_otg_ft_pd  "SPEED11, PD=14kOhm"
io8p11_id_otg_ft_pu  "SPEED11, PU=14kOhm"
io8p11_id_otg_ft  "SPEED11"
[Model Selector] io8usb_lsfs_otg_ft
io8usb_ls_otg_ft_dpdn_pd  "LS USB DP/DN IO + PD=20kOhm"
io8usb_ls_otg_ft_dpdn_pupu2  "LS USB DP/DN IO + PU/PU2=2.2kOhm"
io8usb_ls_otg_ft_dpdn_pu2  "LS USB DP/DN IO + PU2=1.2kOhm"
io8usb_ls_otg_ft_dpdn_pu  "LS USB DP/DN IO + PU=1.2kOhm"
io8usb_ls_otg_ft_dpdn  "LS USB DP/DN IO"
io8usb_fs_otg_ft_dpdn_pd  "HS USB DP/DN IO + PD=20kOhm"
io8usb_fs_otg_ft_dpdn_pupu2  "HS USB DP/DN IO + PU/PU2=2.2kOhm"
io8usb_fs_otg_ft_dpdn_pu2  "HS USB DP/DN IO + PU2=1.2kOhm"
io8usb_fs_otg_ft_dpdn_pu  "HS USB DP/DN IO + PU=1.2kOhm"
io8usb_fs_otg_ft_dpdn  "HS USB DP/DN IO"
io8p00_lsfs_otg_ft_pd_lv  "SPEED00 1P8V, PD=40kOhm"
io8p00_lsfs_otg_ft_pu_lv  "SPEED00 1P8V, PU=40kOhm"
io8p00_lsfs_otg_ft_lv  "SPEED00 1P8V"
io8p01_lsfs_otg_ft_pd_lv  "SPEED01 1P8V, PD=40kOhm"
io8p01_lsfs_otg_ft_pu_lv  "SPEED01 1P8V, PU=40kOhm"
io8p01_lsfs_otg_ft_lv  "SPEED01 1P8V"
io8p10_lsfs_otg_ft_pd_lv  "SPEED10 1P8V, PD=40kOhm"
io8p10_lsfs_otg_ft_pu_lv  "SPEED10 1P8V, PU=40kOhm"
io8p10_lsfs_otg_ft_lv  "SPEED10 1P8V"
io8p11_lsfs_otg_ft_pd_lv  "SPEED11 1P8V, PD=40kOhm"
io8p11_lsfs_otg_ft_pu_lv  "SPEED11 1P8V, PU=40kOhm"
io8p11_lsfs_otg_ft_lv  "SPEED11 1P8V"
io8p00_lsfs_otg_ft_pd  "SPEED00, PD=40kOhm"
io8p00_lsfs_otg_ft_pu  "SPEED00, PU=40kOhm"
io8p00_lsfs_otg_ft  "SPEED00"
io8p01_lsfs_otg_ft_pd  "SPEED01, PD=40kOhm"
io8p01_lsfs_otg_ft_pu  "SPEED01, PU=40kOhm"
io8p01_lsfs_otg_ft  "SPEED01"
io8p10_lsfs_otg_ft_pd  "SPEED10, PD=40kOhm"
io8p10_lsfs_otg_ft_pu  "SPEED10, PU=40kOhm"
io8p10_lsfs_otg_ft  "SPEED10"
io8p11_lsfs_otg_ft_pd  "SPEED11, PD=40kOhm"
io8p11_lsfs_otg_ft_pu  "SPEED11, PU=40kOhm"
io8p11_lsfs_otg_ft  "SPEED11"
[Model Selector] io8usb_vbus_otg_ft
io8psenb_vbus_otg_ft  "VBUS PULSE, SENSE VB"
io8psenab_vbus_otg_ft  "VBUS PULSE, SENSE VA and VB"
io8psena_vbus_otg_ft  "VBUS PULSE, SENSE VA"
io8psen_vbus_otg_ft  "VBUS PULSE"
io8p00_vbus_otg_ft_pd_lv  "SPEED00 1P8V, PD=40kOhm"
io8p00_vbus_otg_ft_pu_lv  "SPEED00 1P8V, PU=40kOhm"
io8p00_vbus_otg_ft_lv  "SPEED00 1P8V"
io8p01_vbus_otg_ft_pd_lv  "SPEED01 1P8V, PD=40kOhm"
io8p01_vbus_otg_ft_pu_lv  "SPEED01 1P8V, PU=40kOhm"
io8p01_vbus_otg_ft_lv  "SPEED01 1P8V"
io8p10_vbus_otg_ft_pd_lv  "SPEED10 1P8V, PD=40kOhm"
io8p10_vbus_otg_ft_pu_lv  "SPEED10 1P8V, PU=40kOhm"
io8p10_vbus_otg_ft_lv  "SPEED10 1P8V"
io8p11_vbus_otg_ft_pd_lv  "SPEED11 1P8V, PD=40kOhm"
io8p11_vbus_otg_ft_pu_lv  "SPEED11 1P8V, PU=40kOhm"
io8p11_vbus_otg_ft_lv  "SPEED11 1P8V"
io8p00_vbus_otg_ft_pd  "SPEED00, PD=40kOhm"
io8p00_vbus_otg_ft_pu  "SPEED00, PU=40kOhm"
io8p00_vbus_otg_ft  "SPEED00"
io8p01_vbus_otg_ft_pd  "SPEED01, PD=40kOhm"
io8p01_vbus_otg_ft_pu  "SPEED01, PU=40kOhm"
io8p01_vbus_otg_ft  "SPEED01"
io8p10_vbus_otg_ft_pd  "SPEED10, PD=40kOhm"
io8p10_vbus_otg_ft_pu  "SPEED10, PU=40kOhm"
io8p10_vbus_otg_ft  "SPEED10"
io8p11_vbus_otg_ft_pd  "SPEED11, PD=40kOhm"
io8p11_vbus_otg_ft_pu  "SPEED11, PU=40kOhm"
io8p11_vbus_otg_ft  "SPEED11"
[Model Selector] ioreset_ft_v33
ioreset_ft_v33_pu_lv  "ioreset 1P8V + PU=40kOhm"
ioreset_ft_v33_nopu_lv  "ioreset 1P8V"
ioreset_ft_v33_pu  "ioreset + PU=40kOhm"
ioreset_ft_v33_nopu  "ioreset"
[Model Selector] vpp_test_hv
vpp_test_hv_2p4  "Input Buffer 1P8V"
vpp_test_hv_3p3  "Input Buffer"
| Models and submodels in the file (260): io8p00_ar3wsudq_ft_pd_lv (I/O), io8p00_ar3wsudq_ft_pu_lv (I/O), io8p00_ar3wsudq_ft_lv (I/O), io8p01_ar3wsudq_ft_pd_lv (I/O), io8p01_ar3wsudq_ft_pu_lv (I/O), io8p01_ar3wsudq_ft_lv (I/O), io8p10_ar3wsudq_ft_pd_lv (I/O), io8p10_ar3wsudq_ft_pu_lv (I/O), io8p10_ar3wsudq_ft_lv (I/O), io8p11_ar3wsudq_ft_pd_lv (I/O), io8p11_ar3wsudq_ft_pu_lv (I/O), io8p11_ar3wsudq_ft_lv (I/O), io8p00_ar3wsudq_ft_pd (I/O), io8p00_ar3wsudq_ft_pu (I/O), io8p00_ar3wsudq_ft (I/O), io8p01_ar3wsudq_ft_pd (I/O), io8p01_ar3wsudq_ft_pu (I/O), io8p01_ar3wsudq_ft (I/O), io8p10_ar3wsudq_ft_pd (I/O), io8p10_ar3wsudq_ft_pu (I/O), io8p10_ar3wsudq_ft (I/O), io8p11_ar3wsudq_ft_pd (I/O), io8p11_ar3wsudq_ft_pu (I/O), io8p11_ar3wsudq_ft (I/O), io8p00_ar3wsudq_ft_v33_pd_lv (I/O), io8p00_ar3wsudq_ft_v33_pu_lv (I/O), io8p00_ar3wsudq_ft_v33_lv (I/O), io8p01_ar3wsudq_ft_v33_pd_lv (I/O), io8p01_ar3wsudq_ft_v33_pu_lv (I/O), io8p01_ar3wsudq_ft_v33_lv (I/O), io8p10_ar3wsudq_ft_v33_pd_lv (I/O), io8p10_ar3wsudq_ft_v33_pu_lv (I/O), io8p10_ar3wsudq_ft_v33_lv (I/O), io8p11_ar3wsudq_ft_v33_pd_lv (I/O), io8p11_ar3wsudq_ft_v33_pu_lv (I/O), io8p11_ar3wsudq_ft_v33_lv (I/O), io8p00_ar3wsudq_ft_v33_pd (I/O), io8p00_ar3wsudq_ft_v33_pu (I/O), io8p00_ar3wsudq_ft_v33 (I/O), io8p01_ar3wsudq_ft_v33_pd (I/O), io8p01_ar3wsudq_ft_v33_pu (I/O), io8p01_ar3wsudq_ft_v33 (I/O), io8p10_ar3wsudq_ft_v33_pd (I/O), io8p10_ar3wsudq_ft_v33_pu (I/O), io8p10_ar3wsudq_ft_v33 (I/O), io8p11_ar3wsudq_ft_v33_pd (I/O), io8p11_ar3wsudq_ft_v33_pu (I/O), io8p11_ar3wsudq_ft_v33 (I/O), io8p00_arsudq_ft_pd_lv (I/O), io8p00_arsudq_ft_pu_lv (I/O), io8p00_arsudq_ft_lv (I/O), io8p01_arsudq_ft_pd_lv (I/O), io8p01_arsudq_ft_pu_lv (I/O), io8p01_arsudq_ft_lv (I/O), io8p10_arsudq_ft_pd_lv (I/O), io8p10_arsudq_ft_pu_lv (I/O), io8p10_arsudq_ft_lv (I/O), io8p11_arsudq_ft_pd_lv (I/O), io8p11_arsudq_ft_pu_lv (I/O), io8p11_arsudq_ft_lv (I/O), io8p00_arsudq_ft_pd (I/O), io8p00_arsudq_ft_pu (I/O), io8p00_arsudq_ft (I/O), io8p01_arsudq_ft_pd (I/O), io8p01_arsudq_ft_pu (I/O), io8p01_arsudq_ft (I/O), io8p10_arsudq_ft_pd (I/O), io8p10_arsudq_ft_pu (I/O), io8p10_arsudq_ft (I/O), io8p11_arsudq_ft_pd (I/O), io8p11_arsudq_ft_pu (I/O), io8p11_arsudq_ft (I/O), io8p00_arsudq_ft_v33_pd_lv (I/O), io8p00_arsudq_ft_v33_pu_lv (I/O), io8p00_arsudq_ft_v33_lv (I/O), io8p01_arsudq_ft_v33_pd_lv (I/O), io8p01_arsudq_ft_v33_pu_lv (I/O), io8p01_arsudq_ft_v33_lv (I/O), io8p10_arsudq_ft_v33_pd_lv (I/O), io8p10_arsudq_ft_v33_pu_lv (I/O)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
