|   stm32f405_415_407_417_lqfp100 IBIS Model
[IBIS ver]   4.2
[File name]  stm32f405_415_407_417_lqfp100.ibs
[File Rev]   1.3
[Date]   05-30-2014
[Source] Data Created at STMicroelectronics
[Notes]   File originated from ELDO simulations.
[Disclaimer]  This information is for modeling purpose only and is
   not guaranted. The information is subject to change without
   notice.
[Copyright] Copyright 2014 STMicroelectronics Inc.
[Component] stm32f405_415_407_417_lqfp100
[Manufacturer] STMicroelectronics
[Package]
| variable   typ   min   max
R_pkg   0.0   NA   NA
L_pkg   0.0H   NA   NA
C_pkg   0.0F   NA   NA
[Pin]   signal_name   model_name   R_pin   L_pin   C_pin
1   PE2   io8p_arsudq_ft   1.324E-01   7.034E-09   1.350E-13
2   PE3   io8p_arsudq_ft   1.333E-01   6.765E-09   1.950E-14
3   PE4   io8p_arsudq_ft   1.290E-01   6.495E-09   1.040E-14
4   PE5   io8p_arsudq_ft   1.253E-01   6.206E-09   5.240E-15
5   PE6   io8p_arsudq_ft   1.205E-01   5.991E-09   7.820E-15
6   VBAT   POWER   1.205E-01   5.950E-09   6.530E-15
7   PC13   io8p_arwsudq_ft_v33   1.179E-01   5.783E-09   6.230E-15
8   PC14   io8p_arwsudq_ft   1.173E-01   5.654E-09   3.110E-15
9   PC15   io8p_arsudq_ft   1.155E-01   5.548E-09   1.390E-15
10   VSS   GND   1.150E-01   5.434E-09   2.920E-15
11   VDD   POWER   1.130E-01   5.296E-09   3.560E-15
12   PH0   io8p_arsudq_ft   1.113E-01   5.231E-09   4.780E-15
13   PH1   io8p_arsudq_ft   1.092E-01   5.142E-09   8.660E-15
14   NRST   ioreset_ft_v33   1.107E-01   5.180E-09   9.030E-15
15   PC0   io8p_ar3wsudq_ft   1.106E-01   5.192E-09   7.980E-15
16   PC1   io8p_ar3wsudq_ft   1.113E-01   5.252E-09   1.030E-14
17   PC2   io8p_ar3wsudq_ft   1.144E-01   5.345E-09   7.000E-15
18   PC3   io8p_ar3wsudq_ft   1.144E-01   5.454E-09   8.650E-15
19   VDD   POWER   1.176E-01   5.621E-09   7.825E-15
20   VREFM   POWER   1.199E-01   5.800E-09   2.290E-16
21   VREFP   POWER   1.223E-01   5.963E-09   1.050E-15
22   VDDA   POWER   1.254E-01   6.187E-09   8.120E-16
23   PA0   io8p_ar3wsudq_ft_v33   1.297E-01   6.485E-09   3.820E-15
24   PA1   io8p_ar3wsudq_ft   1.323E-01   6.715E-09   6.800E-15
25   PA2   io8p_ar3wsudq_ft   1.330E-01   7.014E-09   1.670E-14
26   PA3   io8p_ar3wsudq_ft   1.339E-01   7.050E-09   1.750E-14
27   VSS   GND   1.350E-01   6.804E-09   1.270E-14
28   VDD   POWER   1.305E-01   6.528E-09   9.830E-15
29   PA4   io8p_ar3wsudq_ft   1.254E-01   6.245E-09   6.070E-15
30   PA5   io8p_ar3wsudq_ft   1.250E-01   6.108E-09   5.770E-16
31   PA6   io8p_ar3wsudq_ft   1.218E-01   5.890E-09   1.520E-15
32   PA7   io8p_ar3wsudq_ft   1.191E-01   5.716E-09   5.440E-15
33   PC4   io8p_ar3wsudq_ft   1.164E-01   5.556E-09   4.100E-15
34   PC5   io8p_ar3wsudq_ft   1.133E-01   5.415E-09   3.690E-15
35   PB0   io8p_ar3wsudq_ft   1.127E-01   5.358E-09   3.895E-15
36   PB1   io8p_ar3wsudq_ft   1.123E-01   5.272E-09   1.660E-15
37   PB2   io8p_ar3wsudq_ft   1.118E-01   5.238E-09   7.920E-15
38   PE7   io8p_arsudq_ft   1.110E-01   5.184E-09   9.900E-15
39   PE8   io8p_arsudq_ft   1.146E-01   5.299E-09   7.910E-15
40   PE9   io8p_arsudq_ft   1.145E-01   5.333E-09   7.940E-15
41   PE10   io8p_arsudq_ft   1.154E-01   5.424E-09   4.180E-15
42   PE11   io8p_arsudq_ft   1.170E-01   5.533E-09   6.060E-15
43   PE12   io8p_arsudq_ft   1.202E-01   5.698E-09   5.120E-15
44   PE13   io8p_arsudq_ft   1.226E-01   5.871E-09   4.740E-15
45   PE14   io8p_arsudq_ft   1.263E-01   6.069E-09   1.160E-14
46   PE15   io8p_ar3wsudq_ft   1.297E-01   6.277E-09   9.910E-15
47   PB10   io8p_arsudq_i2cin_ft   1.334E-01   6.508E-09   5.080E-15
48   PB11   io8p_arsudq_i2cin_ft   1.379E-01   6.857E-09   5.470E-15
49   VCAP1   POWER   1.316E-01   6.802E-09   4.180E-15
50   VDD   POWER   1.323E-01   7.042E-09   1.190E-14
51   PB12   io8usb_id_otg_ft   1.318E-01   7.008E-09   1.620E-14
52   PB13   io8usb_vbus_otg_ft   1.318E-01   6.751E-09   2.150E-15
53   PB14   io8usb_lsfs_otg_ft   1.292E-01   6.483E-09   9.175E-15
54   PB15   io8usb_lsfs_otg_ft   1.252E-01   6.202E-09   5.663E-15
55   PD8   io8p_arsudq_ft   1.215E-01   5.986E-09   3.690E-15
56   PD9   io8p_arsudq_ft   1.189E-01   5.807E-09   7.430E-15
57   PD10   io8p_arsudq_ft   1.159E-01   5.635E-09   1.060E-14
58   PD11   io8p_arsudq_ft   1.132E-01   5.471E-09   5.760E-15
59   PD12   io8p_arsudq_ft   1.118E-01   5.354E-09   6.530E-15
60   PD13   io8p_arsudq_ft   1.107E-01   5.276E-09   1.140E-14
61   PD14   io8p_arsudq_ft   1.101E-01   5.204E-09   1.320E-14
62   PD15   io8p_arsudq_ft   1.100E-01   5.180E-09   1.460E-14
63   PC6   io8p_arsudq_ft   1.098E-01   5.154E-09   7.250E-15
64   PC7   io8p_arsudq_ft   1.124E-01   5.258E-09   3.590E-16
65   PC8   io8p_arsudq_ft   1.136E-01   5.332E-09   6.580E-16
66   PC9   io8p_arsudq_i2cin_ft   1.157E-01   5.466E-09   5.085E-16
67   PA8   io8p_arsudq_i2cin_ft   1.170E-01   5.598E-09   5.833E-16
68   PA9   io8usb_vbus_otg_ft   1.190E-01   5.762E-09   5.459E-16
69   PA10   io8usb_id_otg_ft   1.207E-01   5.880E-09   1.390E-14
70   PA11   io8usb_lsfs_otg_ft   1.247E-01   6.108E-09   2.500E-14
71   PA12   io8usb_lsfs_otg_ft   1.244E-01   6.161E-09   3.990E-14
72   PA13   io8p_arsudq_ft   1.302E-01   6.404E-09   3.020E-13
73   VCAP2   POWER   1.351E-01   6.824E-09   1.550E-13
74   VSS   GND   1.394E-01   7.077E-09   1.550E-13
75   VDD   POWER   1.336E-01   7.056E-09   3.900E-14
76   PA14   io8p_arsudq_ft   1.353E-01   7.104E-09   1.630E-14
77   PA15   io8p_arsudq_ft   1.325E-01   6.836E-09   9.760E-15
78   PC10   io8p_arsudq_ft   1.335E-01   6.641E-09   9.300E-15
79   PC11   io8p_arsudq_ft   1.284E-01   6.341E-09   5.420E-15
80   PC12   io8p_arsudq_ft   1.243E-01   6.092E-09   1.180E-15
81   PD0   io8p_arsudq_ft   1.218E-01   5.917E-09   5.460E-15
82   PD1   io8p_arsudq_ft   1.185E-01   5.728E-09   7.000E-15
83   PD2   io8p_arsudq_ft   1.172E-01   5.573E-09   6.060E-15
84   PD3   io8p_arsudq_ft   1.135E-01   5.422E-09   5.450E-15
85   PD4   io8p_arsudq_ft   1.138E-01   5.344E-09   5.290E-16
86   PD5   io8p_arsudq_ft   1.108E-01   5.256E-09   2.990E-15
87   PD6   io8p_arsudq_ft   1.104E-01   5.246E-09   2.060E-15
88   PD7   io8p_arsudq_ft   1.115E-01   5.178E-09   5.680E-15
89   PB3   io8p_arsudq_ft   1.111E-01   5.223E-09   9.910E-15
90   PB4   io8p_arsudq_ft   1.132E-01   5.310E-09   9.050E-15
91   PB5   io8p_ar3wsudq_ft   1.133E-01   5.401E-09   1.290E-14
92   PB6   io8p_arsudq_i2cin_ft   1.158E-01   5.519E-09   1.260E-14
93   PB7   io8p_arsudq_i2cin_ft   1.176E-01   5.673E-09   6.140E-15
94   BOOT0   vpp_test_hv   1.190E-01   5.802E-09   9.370E-15
95   PB8   io8p_arsudq_i2cin_ft   1.219E-01   5.962E-09   7.755E-15
96   PB9   io8p_arsudq_i2cin_ft   1.263E-01   6.158E-09   8.563E-15
97   PE0   io8p_arsudq_ft   1.287E-01   6.367E-09   8.159E-15
98   PE1   io8p_arsudq_ft   1.333E-01   6.700E-09   1.030E-15
99   VSS   GND   1.322E-01   6.844E-09   4.410E-15
100   VDD   POWER   1.323E-01   7.052E-09   1.710E-14
[Diff Pin]   inv_pin   vdiff   tdelay_typ  tdelay_min  tdelay_max
54   53   200mV   NA   NA   NA
71   70   200mV   NA   NA   NA
[Model Selector] io8p_ar3wsudq_ft
io8p00_ar3wsudq_ft_pd_lv  "SPEED00 1P8V, PD=40kOhm"
io8p00_ar3wsudq_ft_pu_lv  "SPEED00 1P8V, PU=40kOhm"
io8p00_ar3wsudq_ft_lv  "SPEED00 1P8V"
io8p01_ar3wsudq_ft_pd_lv  "SPEED01 1P8V, PD=40kOhm"
io8p01_ar3wsudq_ft_pu_lv  "SPEED01 1P8V, PU=40kOhm"
io8p01_ar3wsudq_ft_lv  "SPEED01 1P8V"
io8p10_ar3wsudq_ft_pd_lv  "SPEED10 1P8V, PD=40kOhm"
io8p10_ar3wsudq_ft_pu_lv  "SPEED10 1P8V, PU=40kOhm"
io8p10_ar3wsudq_ft_lv  "SPEED10 1P8V"
io8p11_ar3wsudq_ft_pd_lv  "SPEED11 1P8V, PD=40kOhm"
io8p11_ar3wsudq_ft_pu_lv  "SPEED11 1P8V, PU=40kOhm"
io8p11_ar3wsudq_ft_lv  "SPEED11 1P8V"
io8p00_ar3wsudq_ft_pd  "SPEED00, PD=40kOhm"
io8p00_ar3wsudq_ft_pu  "SPEED00, PU=40kOhm"
io8p00_ar3wsudq_ft  "SPEED00"
io8p01_ar3wsudq_ft_pd  "SPEED01, PD=40kOhm"
io8p01_ar3wsudq_ft_pu  "SPEED01, PU=40kOhm"
io8p01_ar3wsudq_ft  "SPEED01"
io8p10_ar3wsudq_ft_pd  "SPEED10, PD=40kOhm"
io8p10_ar3wsudq_ft_pu  "SPEED10, PU=40kOhm"
io8p10_ar3wsudq_ft  "SPEED10"
io8p11_ar3wsudq_ft_pd  "SPEED11, PD=40kOhm"
io8p11_ar3wsudq_ft_pu  "SPEED11, PU=40kOhm"
io8p11_ar3wsudq_ft  "SPEED11"
[Model Selector] io8p_ar3wsudq_ft_v33
io8p00_ar3wsudq_ft_v33_pd_lv  "SPEED00 1P8V, PD=40kOhm"
io8p00_ar3wsudq_ft_v33_pu_lv  "SPEED00 1P8V, PU=40kOhm"
io8p00_ar3wsudq_ft_v33_lv  "SPEED00 1P8V"
io8p01_ar3wsudq_ft_v33_pd_lv  "SPEED01 1P8V, PD=40kOhm"
io8p01_ar3wsudq_ft_v33_pu_lv  "SPEED01 1P8V, PU=40kOhm"
io8p01_ar3wsudq_ft_v33_lv  "SPEED01 1P8V"
io8p10_ar3wsudq_ft_v33_pd_lv  "SPEED10 1P8V, PD=40kOhm"
io8p10_ar3wsudq_ft_v33_pu_lv  "SPEED10 1P8V, PU=40kOhm"
io8p10_ar3wsudq_ft_v33_lv  "SPEED10 1P8V"
io8p11_ar3wsudq_ft_v33_pd_lv  "SPEED11 1P8V, PD=40kOhm"
io8p11_ar3wsudq_ft_v33_pu_lv  "SPEED11 1P8V, PU=40kOhm"
io8p11_ar3wsudq_ft_v33_lv  "SPEED11 1P8V"
io8p00_ar3wsudq_ft_v33_pd  "SPEED00, PD=40kOhm"
io8p00_ar3wsudq_ft_v33_pu  "SPEED00, PU=40kOhm"
io8p00_ar3wsudq_ft_v33  "SPEED00"
io8p01_ar3wsudq_ft_v33_pd  "SPEED01, PD=40kOhm"
io8p01_ar3wsudq_ft_v33_pu  "SPEED01, PU=40kOhm"
io8p01_ar3wsudq_ft_v33  "SPEED01"
io8p10_ar3wsudq_ft_v33_pd  "SPEED10, PD=40kOhm"
io8p10_ar3wsudq_ft_v33_pu  "SPEED10, PU=40kOhm"
io8p10_ar3wsudq_ft_v33  "SPEED10"
io8p11_ar3wsudq_ft_v33_pd  "SPEED11, PD=40kOhm"
io8p11_ar3wsudq_ft_v33_pu  "SPEED11, PU=40kOhm"
io8p11_ar3wsudq_ft_v33  "SPEED11"
[Model Selector] io8p_arsudq_ft
io8p00_arsudq_ft_pd_lv  "SPEED00 1P8V, PD=40kOhm"
io8p00_arsudq_ft_pu_lv  "SPEED00 1P8V, PU=40kOhm"
io8p00_arsudq_ft_lv  "SPEED00 1P8V"
io8p01_arsudq_ft_pd_lv  "SPEED01 1P8V, PD=40kOhm"
io8p01_arsudq_ft_pu_lv  "SPEED01 1P8V, PU=40kOhm"
io8p01_arsudq_ft_lv  "SPEED01 1P8V"
io8p10_arsudq_ft_pd_lv  "SPEED10 1P8V, PD=40kOhm"
io8p10_arsudq_ft_pu_lv  "SPEED10 1P8V, PU=40kOhm"
io8p10_arsudq_ft_lv  "SPEED10 1P8V"
io8p11_arsudq_ft_pd_lv  "SPEED11 1P8V, PD=40kOhm"
io8p11_arsudq_ft_pu_lv  "SPEED11 1P8V, PU=40kOhm"
io8p11_arsudq_ft_lv  "SPEED11 1P8V"
io8p00_arsudq_ft_pd  "SPEED00, PD=40kOhm"
io8p00_arsudq_ft_pu  "SPEED00, PU=40kOhm"
io8p00_arsudq_ft  "SPEED00"
io8p01_arsudq_ft_pd  "SPEED01, PD=40kOhm"
io8p01_arsudq_ft_pu  "SPEED01, PU=40kOhm"
io8p01_arsudq_ft  "SPEED01"
io8p10_arsudq_ft_pd  "SPEED10, PD=40kOhm"
io8p10_arsudq_ft_pu  "SPEED10, PU=40kOhm"
io8p10_arsudq_ft  "SPEED10"
io8p11_arsudq_ft_pd  "SPEED11, PD=40kOhm"
io8p11_arsudq_ft_pu  "SPEED11, PU=40kOhm"
io8p11_arsudq_ft  "SPEED11"
[Model Selector] io8p_arsudq_ft_v33
io8p00_arsudq_ft_v33_pd_lv  "SPEED00 1P8V, PD=40kOhm"
io8p00_arsudq_ft_v33_pu_lv  "SPEED00 1P8V, PU=40kOhm"
io8p00_arsudq_ft_v33_lv  "SPEED00 1P8V"
io8p01_arsudq_ft_v33_pd_lv  "SPEED01 1P8V, PD=40kOhm"
io8p01_arsudq_ft_v33_pu_lv  "SPEED01 1P8V, PU=40kOhm"
io8p01_arsudq_ft_v33_lv  "SPEED01 1P8V"
io8p10_arsudq_ft_v33_pd_lv  "SPEED10 1P8V, PD=40kOhm"
io8p10_arsudq_ft_v33_pu_lv  "SPEED10 1P8V, PU=40kOhm"
io8p10_arsudq_ft_v33_lv  "SPEED10 1P8V"
io8p11_arsudq_ft_v33_pd_lv  "SPEED11 1P8V, PD=40kOhm"
io8p11_arsudq_ft_v33_pu_lv  "SPEED11 1P8V, PU=40kOhm"
io8p11_arsudq_ft_v33_lv  "SPEED11 1P8V"
io8p00_arsudq_ft_v33_pd  "SPEED00, PD=40kOhm"
io8p00_arsudq_ft_v33_pu  "SPEED00, PU=40kOhm"
io8p00_arsudq_ft_v33  "SPEED00"
io8p01_arsudq_ft_v33_pd  "SPEED01, PD=40kOhm"
io8p01_arsudq_ft_v33_pu  "SPEED01, PU=40kOhm"
io8p01_arsudq_ft_v33  "SPEED01"
io8p10_arsudq_ft_v33_pd  "SPEED10, PD=40kOhm"
io8p10_arsudq_ft_v33_pu  "SPEED10, PU=40kOhm"
io8p10_arsudq_ft_v33  "SPEED10"
io8p11_arsudq_ft_v33_pd  "SPEED11, PD=40kOhm"
io8p11_arsudq_ft_v33_pu  "SPEED11, PU=40kOhm"
io8p11_arsudq_ft_v33  "SPEED11"
[Model Selector] io8p_arsudq_i2cin_ft
io8p00_arsudq_i2cin_ft_pd_lv  "SPEED00 1P8V, PD=40kOhm"
io8p00_arsudq_i2cin_ft_pu_lv  "SPEED00 1P8V, PU=40kOhm"
io8p00_arsudq_i2cin_ft_lv  "SPEED00 1P8V"
io8p01_arsudq_i2cin_ft_pd_lv  "SPEED01 1P8V, PD=40kOhm"
io8p01_arsudq_i2cin_ft_pu_lv  "SPEED01 1P8V, PU=40kOhm"
io8p01_arsudq_i2cin_ft_lv  "SPEED01 1P8V"
io8p10_arsudq_i2cin_ft_pd_lv  "SPEED10 1P8V, PD=40kOhm"
io8p10_arsudq_i2cin_ft_pu_lv  "SPEED10 1P8V, PU=40kOhm"
io8p10_arsudq_i2cin_ft_lv  "SPEED10 1P8V"
io8p11_arsudq_i2cin_ft_pd_lv  "SPEED11 1P8V, PD=40kOhm"
io8p11_arsudq_i2cin_ft_pu_lv  "SPEED11 1P8V, PU=40kOhm"
io8p11_arsudq_i2cin_ft_lv  "SPEED11 1P8V"
io8p00_arsudq_i2cin_ft_pd  "SPEED00, PD=40kOhm"
io8p00_arsudq_i2cin_ft_pu  "SPEED00, PU=40kOhm"
io8p00_arsudq_i2cin_ft  "SPEED00"
io8p01_arsudq_i2cin_ft_pd  "SPEED01, PD=40kOhm"
io8p01_arsudq_i2cin_ft_pu  "SPEED01, PU=40kOhm"
io8p01_arsudq_i2cin_ft  "SPEED01"
io8p10_arsudq_i2cin_ft_pd  "SPEED10, PD=40kOhm"
io8p10_arsudq_i2cin_ft_pu  "SPEED10, PU=40kOhm"
io8p10_arsudq_i2cin_ft  "SPEED10"
io8p11_arsudq_i2cin_ft_pd  "SPEED11, PD=40kOhm"
io8p11_arsudq_i2cin_ft_pu  "SPEED11, PU=40kOhm"
io8p11_arsudq_i2cin_ft  "SPEED11"
[Model Selector] io8p_arwsudq_ft
io8p00_arwsudq_ft_pd_lv  "SPEED00 1P8V, PD=40kOhm"
io8p00_arwsudq_ft_pu_lv  "SPEED00 1P8V, PU=40kOhm"
io8p00_arwsudq_ft_lv  "SPEED00 1P8V"
io8p01_arwsudq_ft_pd_lv  "SPEED01 1P8V, PD=40kOhm"
io8p01_arwsudq_ft_pu_lv  "SPEED01 1P8V, PU=40kOhm"
io8p01_arwsudq_ft_lv  "SPEED01 1P8V"
io8p10_arwsudq_ft_pd_lv  "SPEED10 1P8V, PD=40kOhm"
io8p10_arwsudq_ft_pu_lv  "SPEED10 1P8V, PU=40kOhm"
io8p10_arwsudq_ft_lv  "SPEED10 1P8V"
io8p11_arwsudq_ft_pd_lv  "SPEED11 1P8V, PD=40kOhm"
io8p11_arwsudq_ft_pu_lv  "SPEED11 1P8V, PU=40kOhm"
io8p11_arwsudq_ft_lv  "SPEED11 1P8V"
io8p00_arwsudq_ft_pd  "SPEED00, PD=40kOhm"
io8p00_arwsudq_ft_pu  "SPEED00, PU=40kOhm"
io8p00_arwsudq_ft  "SPEED00"
io8p01_arwsudq_ft_pd  "SPEED01, PD=40kOhm"
io8p01_arwsudq_ft_pu  "SPEED01, PU=40kOhm"
io8p01_arwsudq_ft  "SPEED01"
io8p10_arwsudq_ft_pd  "SPEED10, PD=40kOhm"
io8p10_arwsudq_ft_pu  "SPEED10, PU=40kOhm"
io8p10_arwsudq_ft  "SPEED10"
io8p11_arwsudq_ft_pd  "SPEED11, PD=40kOhm"
io8p11_arwsudq_ft_pu  "SPEED11, PU=40kOhm"
io8p11_arwsudq_ft  "SPEED11"
[Model Selector] io8p_arwsudq_ft_v33
io8p00_arwsudq_ft_v33_pd_lv  "SPEED00 1P8V, PD=40kOhm"
io8p00_arwsudq_ft_v33_pu_lv  "SPEED00 1P8V, PU=40kOhm"
io8p00_arwsudq_ft_v33_lv  "SPEED00 1P8V"
io8p01_arwsudq_ft_v33_pd_lv  "SPEED01 1P8V, PD=40kOhm"
io8p01_arwsudq_ft_v33_pu_lv  "SPEED01 1P8V, PU=40kOhm"
io8p01_arwsudq_ft_v33_lv  "SPEED01 1P8V"
io8p10_arwsudq_ft_v33_pd_lv  "SPEED10 1P8V, PD=40kOhm"
io8p10_arwsudq_ft_v33_pu_lv  "SPEED10 1P8V, PU=40kOhm"
io8p10_arwsudq_ft_v33_lv  "SPEED10 1P8V"
io8p11_arwsudq_ft_v33_pd_lv  "SPEED11 1P8V, PD=40kOhm"
io8p11_arwsudq_ft_v33_pu_lv  "SPEED11 1P8V, PU=40kOhm"
io8p11_arwsudq_ft_v33_lv  "SPEED11 1P8V"
io8p00_arwsudq_ft_v33_pd  "SPEED00, PD=40kOhm"
io8p00_arwsudq_ft_v33_pu  "SPEED00, PU=40kOhm"
io8p00_arwsudq_ft_v33  "SPEED00"
io8p01_arwsudq_ft_v33_pd  "SPEED01, PD=40kOhm"
io8p01_arwsudq_ft_v33_pu  "SPEED01, PU=40kOhm"
io8p01_arwsudq_ft_v33  "SPEED01"
io8p10_arwsudq_ft_v33_pd  "SPEED10, PD=40kOhm"
io8p10_arwsudq_ft_v33_pu  "SPEED10, PU=40kOhm"
io8p10_arwsudq_ft_v33  "SPEED10"
io8p11_arwsudq_ft_v33_pd  "SPEED11, PD=40kOhm"
io8p11_arwsudq_ft_v33_pu  "SPEED11, PU=40kOhm"
io8p11_arwsudq_ft_v33  "SPEED11"
[Model Selector] io8usb_id_otg_ft
io8p00_id_otg_ft_pd_lv  "SPEED00 1P8V, PD=14kOhm"
io8p00_id_otg_ft_pu_lv  "SPEED00 1P8V, PU=14kOhm"
io8p00_id_otg_ft_lv  "SPEED00 1P8V"
io8p01_id_otg_ft_pd_lv  "SPEED01 1P8V, PD=14kOhm"
io8p01_id_otg_ft_pu_lv  "SPEED01 1P8V, PU=14kOhm"
io8p01_id_otg_ft_lv  "SPEED01 1P8V"
io8p10_id_otg_ft_pd_lv  "SPEED10 1P8V, PD=14kOhm"
io8p10_id_otg_ft_pu_lv  "SPEED10 1P8V, PU=14kOhm"
io8p10_id_otg_ft_lv  "SPEED10 1P8V"
io8p11_id_otg_ft_pd_lv  "SPEED11 1P8V, PD=14kOhm"
io8p11_id_otg_ft_pu_lv  "SPEED11 1P8V, PU=14kOhm"
io8p11_id_otg_ft_lv  "SPEED11 1P8V"
io8p00_id_otg_ft_pd  "SPEED00, PD=14kOhm"
io8p00_id_otg_ft_pu  "SPEED00, PU=14kOhm"
io8p00_id_otg_ft  "SPEED00"
io8p01_id_otg_ft_pd  "SPEED01, PD=14kOhm"
io8p01_id_otg_ft_pu  "SPEED01, PU=14kOhm"
io8p01_id_otg_ft  "SPEED01"
io8p10_id_otg_ft_pd  "SPEED10, PD=14kOhm"
io8p10_id_otg_ft_pu  "SPEED10, PU=14kOhm"
io8p10_id_otg_ft  "SPEED10"
io8p11_id_otg_ft_pd  "SPEED11, PD=14kOhm"
io8p11_id_otg_ft_pu  "SPEED11, PU=14kOhm"
io8p11_id_otg_ft  "SPEED11"
[Model Selector] io8usb_lsfs_otg_ft
io8usb_ls_otg_ft_dpdn_pd  "LS USB DP/DN IO + PD=20kOhm"
io8usb_ls_otg_ft_dpdn_pupu2  "LS USB DP/DN IO + PU/PU2=2.2kOhm"
io8usb_ls_otg_ft_dpdn_pu2  "LS USB DP/DN IO + PU2=1.2kOhm"
io8usb_ls_otg_ft_dpdn_pu  "LS USB DP/DN IO + PU=1.2kOhm"
io8usb_ls_otg_ft_dpdn  "LS USB DP/DN IO"
io8usb_fs_otg_ft_dpdn_pd  "HS USB DP/DN IO + PD=20kOhm"
io8usb_fs_otg_ft_dpdn_pupu2  "HS USB DP/DN IO + PU/PU2=2.2kOhm"
io8usb_fs_otg_ft_dpdn_pu2  "HS USB DP/DN IO + PU2=1.2kOhm"
io8usb_fs_otg_ft_dpdn_pu  "HS USB DP/DN IO + PU=1.2kOhm"
io8usb_fs_otg_ft_dpdn  "HS USB DP/DN IO"
io8p00_lsfs_otg_ft_pd_lv  "SPEED00 1P8V, PD=40kOhm"
io8p00_lsfs_otg_ft_pu_lv  "SPEED00 1P8V, PU=40kOhm"
io8p00_lsfs_otg_ft_lv  "SPEED00 1P8V"
io8p01_lsfs_otg_ft_pd_lv  "SPEED01 1P8V, PD=40kOhm"
io8p01_lsfs_otg_ft_pu_lv  "SPEED01 1P8V, PU=40kOhm"
io8p01_lsfs_otg_ft_lv  "SPEED01 1P8V"
io8p10_lsfs_otg_ft_pd_lv  "SPEED10 1P8V, PD=40kOhm"
io8p10_lsfs_otg_ft_pu_lv  "SPEED10 1P8V, PU=40kOhm"
io8p10_lsfs_otg_ft_lv  "SPEED10 1P8V"
io8p11_lsfs_otg_ft_pd_lv  "SPEED11 1P8V, PD=40kOhm"
io8p11_lsfs_otg_ft_pu_lv  "SPEED11 1P8V, PU=40kOhm"
io8p11_lsfs_otg_ft_lv  "SPEED11 1P8V"
io8p00_lsfs_otg_ft_pd  "SPEED00, PD=40kOhm"
io8p00_lsfs_otg_ft_pu  "SPEED00, PU=40kOhm"
io8p00_lsfs_otg_ft  "SPEED00"
io8p01_lsfs_otg_ft_pd  "SPEED01, PD=40kOhm"
io8p01_lsfs_otg_ft_pu  "SPEED01, PU=40kOhm"
io8p01_lsfs_otg_ft  "SPEED01"
io8p10_lsfs_otg_ft_pd  "SPEED10, PD=40kOhm"
io8p10_lsfs_otg_ft_pu  "SPEED10, PU=40kOhm"
io8p10_lsfs_otg_ft  "SPEED10"
io8p11_lsfs_otg_ft_pd  "SPEED11, PD=40kOhm"
io8p11_lsfs_otg_ft_pu  "SPEED11, PU=40kOhm"
io8p11_lsfs_otg_ft  "SPEED11"
[Model Selector] io8usb_vbus_otg_ft
io8psenb_vbus_otg_ft  "VBUS PULSE, SENSE VB"
io8psenab_vbus_otg_ft  "VBUS PULSE, SENSE VA and VB"
io8psena_vbus_otg_ft  "VBUS PULSE, SENSE VA"
io8psen_vbus_otg_ft  "VBUS PULSE"
io8p00_vbus_otg_ft_pd_lv  "SPEED00 1P8V, PD=40kOhm"
io8p00_vbus_otg_ft_pu_lv  "SPEED00 1P8V, PU=40kOhm"
io8p00_vbus_otg_ft_lv  "SPEED00 1P8V"
io8p01_vbus_otg_ft_pd_lv  "SPEED01 1P8V, PD=40kOhm"
io8p01_vbus_otg_ft_pu_lv  "SPEED01 1P8V, PU=40kOhm"
io8p01_vbus_otg_ft_lv  "SPEED01 1P8V"
io8p10_vbus_otg_ft_pd_lv  "SPEED10 1P8V, PD=40kOhm"
io8p10_vbus_otg_ft_pu_lv  "SPEED10 1P8V, PU=40kOhm"
io8p10_vbus_otg_ft_lv  "SPEED10 1P8V"
io8p11_vbus_otg_ft_pd_lv  "SPEED11 1P8V, PD=40kOhm"
io8p11_vbus_otg_ft_pu_lv  "SPEED11 1P8V, PU=40kOhm"
io8p11_vbus_otg_ft_lv  "SPEED11 1P8V"
io8p00_vbus_otg_ft_pd  "SPEED00, PD=40kOhm"
io8p00_vbus_otg_ft_pu  "SPEED00, PU=40kOhm"
io8p00_vbus_otg_ft  "SPEED00"
io8p01_vbus_otg_ft_pd  "SPEED01, PD=40kOhm"
io8p01_vbus_otg_ft_pu  "SPEED01, PU=40kOhm"
io8p01_vbus_otg_ft  "SPEED01"
io8p10_vbus_otg_ft_pd  "SPEED10, PD=40kOhm"
io8p10_vbus_otg_ft_pu  "SPEED10, PU=40kOhm"
io8p10_vbus_otg_ft  "SPEED10"
io8p11_vbus_otg_ft_pd  "SPEED11, PD=40kOhm"
io8p11_vbus_otg_ft_pu  "SPEED11, PU=40kOhm"
io8p11_vbus_otg_ft  "SPEED11"
[Model Selector] ioreset_ft_v33
ioreset_ft_v33_pu_lv  "ioreset 1P8V + PU=40kOhm"
ioreset_ft_v33_nopu_lv  "ioreset 1P8V"
ioreset_ft_v33_pu  "ioreset + PU=40kOhm"
ioreset_ft_v33_nopu  "ioreset"
[Model Selector] vpp_test_hv
vpp_test_hv_2p4  "Input Buffer 1P8V"
vpp_test_hv_3p3  "Input Buffer"
| Models and submodels in the file (260): io8p00_ar3wsudq_ft_pd_lv (I/O), io8p00_ar3wsudq_ft_pu_lv (I/O), io8p00_ar3wsudq_ft_lv (I/O), io8p01_ar3wsudq_ft_pd_lv (I/O), io8p01_ar3wsudq_ft_pu_lv (I/O), io8p01_ar3wsudq_ft_lv (I/O), io8p10_ar3wsudq_ft_pd_lv (I/O), io8p10_ar3wsudq_ft_pu_lv (I/O), io8p10_ar3wsudq_ft_lv (I/O), io8p11_ar3wsudq_ft_pd_lv (I/O), io8p11_ar3wsudq_ft_pu_lv (I/O), io8p11_ar3wsudq_ft_lv (I/O), io8p00_ar3wsudq_ft_pd (I/O), io8p00_ar3wsudq_ft_pu (I/O), io8p00_ar3wsudq_ft (I/O), io8p01_ar3wsudq_ft_pd (I/O), io8p01_ar3wsudq_ft_pu (I/O), io8p01_ar3wsudq_ft (I/O), io8p10_ar3wsudq_ft_pd (I/O), io8p10_ar3wsudq_ft_pu (I/O), io8p10_ar3wsudq_ft (I/O), io8p11_ar3wsudq_ft_pd (I/O), io8p11_ar3wsudq_ft_pu (I/O), io8p11_ar3wsudq_ft (I/O), io8p00_ar3wsudq_ft_v33_pd_lv (I/O), io8p00_ar3wsudq_ft_v33_pu_lv (I/O), io8p00_ar3wsudq_ft_v33_lv (I/O), io8p01_ar3wsudq_ft_v33_pd_lv (I/O), io8p01_ar3wsudq_ft_v33_pu_lv (I/O), io8p01_ar3wsudq_ft_v33_lv (I/O), io8p10_ar3wsudq_ft_v33_pd_lv (I/O), io8p10_ar3wsudq_ft_v33_pu_lv (I/O), io8p10_ar3wsudq_ft_v33_lv (I/O), io8p11_ar3wsudq_ft_v33_pd_lv (I/O), io8p11_ar3wsudq_ft_v33_pu_lv (I/O), io8p11_ar3wsudq_ft_v33_lv (I/O), io8p00_ar3wsudq_ft_v33_pd (I/O), io8p00_ar3wsudq_ft_v33_pu (I/O), io8p00_ar3wsudq_ft_v33 (I/O), io8p01_ar3wsudq_ft_v33_pd (I/O), io8p01_ar3wsudq_ft_v33_pu (I/O), io8p01_ar3wsudq_ft_v33 (I/O), io8p10_ar3wsudq_ft_v33_pd (I/O), io8p10_ar3wsudq_ft_v33_pu (I/O), io8p10_ar3wsudq_ft_v33 (I/O), io8p11_ar3wsudq_ft_v33_pd (I/O), io8p11_ar3wsudq_ft_v33_pu (I/O), io8p11_ar3wsudq_ft_v33 (I/O), io8p00_arsudq_ft_pd_lv (I/O), io8p00_arsudq_ft_pu_lv (I/O), io8p00_arsudq_ft_lv (I/O), io8p01_arsudq_ft_pd_lv (I/O), io8p01_arsudq_ft_pu_lv (I/O), io8p01_arsudq_ft_lv (I/O), io8p10_arsudq_ft_pd_lv (I/O), io8p10_arsudq_ft_pu_lv (I/O), io8p10_arsudq_ft_lv (I/O), io8p11_arsudq_ft_pd_lv (I/O), io8p11_arsudq_ft_pu_lv (I/O), io8p11_arsudq_ft_lv (I/O), io8p00_arsudq_ft_pd (I/O), io8p00_arsudq_ft_pu (I/O), io8p00_arsudq_ft (I/O), io8p01_arsudq_ft_pd (I/O), io8p01_arsudq_ft_pu (I/O), io8p01_arsudq_ft (I/O), io8p10_arsudq_ft_pd (I/O), io8p10_arsudq_ft_pu (I/O), io8p10_arsudq_ft (I/O), io8p11_arsudq_ft_pd (I/O), io8p11_arsudq_ft_pu (I/O), io8p11_arsudq_ft (I/O), io8p00_arsudq_ft_v33_pd_lv (I/O), io8p00_arsudq_ft_v33_pu_lv (I/O), io8p00_arsudq_ft_v33_lv (I/O), io8p01_arsudq_ft_v33_pd_lv (I/O), io8p01_arsudq_ft_v33_pu_lv (I/O), io8p01_arsudq_ft_v33_lv (I/O), io8p10_arsudq_ft_v33_pd_lv (I/O), io8p10_arsudq_ft_v33_pu_lv (I/O)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
